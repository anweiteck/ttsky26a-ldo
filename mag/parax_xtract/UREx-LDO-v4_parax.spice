* NGSPICE file created from UREx-LDO-v4_parax.ext - technology: sky130A

.subckt UREx-LDO-v4_parax VDD VOUT GND Vref
X0 VOUT.t70 XM7.S VDD.t143 VDD.t142 sky130_fd_pr__pfet_01v8_lvt ad=3.625 pd=25.29 as=3.625 ps=25.29 w=25 l=0.35
X1 VOUT.t69 XM7.S VDD.t137 VDD.t136 sky130_fd_pr__pfet_01v8_lvt ad=3.625 pd=25.29 as=3.625 ps=25.29 w=25 l=0.35
X2 XR2.R1 XM13.S XM14.D GND.t4 sky130_fd_pr__nfet_01v8_lvt ad=0.638 pd=4.98 as=0.638 ps=4.98 w=2.2 l=1
X3 XR1.R2 GND.t12 GND.t11 sky130_fd_pr__res_high_po_0p35 l=53.9
X4 VDD.t141 XM7.S VOUT.t68 VDD.t140 sky130_fd_pr__pfet_01v8_lvt ad=3.625 pd=25.29 as=3.625 ps=25.29 w=25 l=0.35
X5 VDD.t139 XM7.S VOUT.t67 VDD.t138 sky130_fd_pr__pfet_01v8_lvt ad=3.625 pd=25.29 as=3.625 ps=25.29 w=25 l=0.35
X6 XR1.R2 VOUT.t0 GND.t0 sky130_fd_pr__res_high_po_0p35 l=35.7
X7 VDD.t135 XM7.S VOUT.t66 VDD.t134 sky130_fd_pr__pfet_01v8_lvt ad=3.625 pd=25.29 as=3.625 ps=25.29 w=25 l=0.35
X8 VOUT.t65 XM7.S VDD.t133 VDD.t132 sky130_fd_pr__pfet_01v8_lvt ad=3.625 pd=25.29 as=3.625 ps=25.29 w=25 l=0.35
X9 VOUT.t64 XM7.S VDD.t109 VDD.t108 sky130_fd_pr__pfet_01v8_lvt ad=3.625 pd=25.29 as=3.625 ps=25.29 w=25 l=0.35
X10 VDD.t111 XM7.S VOUT.t63 VDD.t110 sky130_fd_pr__pfet_01v8_lvt ad=3.625 pd=25.29 as=3.625 ps=25.29 w=25 l=0.35
X11 VDD.t113 XM7.S VOUT.t62 VDD.t112 sky130_fd_pr__pfet_01v8_lvt ad=3.625 pd=25.29 as=3.625 ps=25.29 w=25 l=0.35
X12 VDD.t115 XM7.S VOUT.t61 VDD.t114 sky130_fd_pr__pfet_01v8_lvt ad=3.625 pd=25.29 as=3.625 ps=25.29 w=25 l=0.35
X13 VDD.t131 XM7.S VOUT.t60 VDD.t130 sky130_fd_pr__pfet_01v8_lvt ad=3.625 pd=25.29 as=3.625 ps=25.29 w=25 l=0.35
X14 VDD.t129 XM7.S VOUT.t59 VDD.t128 sky130_fd_pr__pfet_01v8_lvt ad=3.625 pd=25.29 as=3.625 ps=25.29 w=25 l=0.35
X15 VOUT.t58 XM7.S VDD.t127 VDD.t126 sky130_fd_pr__pfet_01v8_lvt ad=3.625 pd=25.29 as=3.625 ps=25.29 w=25 l=0.35
X16 VDD.t117 XM7.S VOUT.t57 VDD.t116 sky130_fd_pr__pfet_01v8_lvt ad=3.625 pd=25.29 as=3.625 ps=25.29 w=25 l=0.35
X17 VDD.t119 XM7.S VOUT.t56 VDD.t118 sky130_fd_pr__pfet_01v8_lvt ad=3.625 pd=25.29 as=3.625 ps=25.29 w=25 l=0.35
X18 VDD.t125 XM7.S VOUT.t55 VDD.t124 sky130_fd_pr__pfet_01v8_lvt ad=3.625 pd=25.29 as=3.625 ps=25.29 w=25 l=0.35
X19 VOUT.t54 XM7.S VDD.t123 VDD.t122 sky130_fd_pr__pfet_01v8_lvt ad=3.625 pd=25.29 as=7.25 ps=50.58 w=25 l=0.35
X20 VDD.t121 XM7.S VOUT.t53 VDD.t120 sky130_fd_pr__pfet_01v8_lvt ad=7.25 pd=50.58 as=3.625 ps=25.29 w=25 l=0.35
X21 VDD.t107 XM7.S VOUT.t52 VDD.t106 sky130_fd_pr__pfet_01v8_lvt ad=3.625 pd=25.29 as=3.625 ps=25.29 w=25 l=0.35
X22 VDD.t105 XM7.S VOUT.t51 VDD.t104 sky130_fd_pr__pfet_01v8_lvt ad=3.625 pd=25.29 as=3.625 ps=25.29 w=25 l=0.35
X23 VOUT.t50 XM7.S VDD.t99 VDD.t98 sky130_fd_pr__pfet_01v8_lvt ad=3.625 pd=25.29 as=3.625 ps=25.29 w=25 l=0.35
X24 VOUT.t49 XM7.S VDD.t101 VDD.t100 sky130_fd_pr__pfet_01v8_lvt ad=3.625 pd=25.29 as=3.625 ps=25.29 w=25 l=0.35
X25 VOUT.t48 XM7.S VDD.t103 VDD.t102 sky130_fd_pr__pfet_01v8_lvt ad=3.625 pd=25.29 as=3.625 ps=25.29 w=25 l=0.35
X26 VOUT.t47 XM7.S VDD.t97 VDD.t96 sky130_fd_pr__pfet_01v8_lvt ad=3.625 pd=25.29 as=7.25 ps=50.58 w=25 l=0.35
X27 GND.t10 XM7.G XM1.S GND.t9 sky130_fd_pr__nfet_01v8_lvt ad=0.348 pd=2.98 as=0.348 ps=2.98 w=1.2 l=1
X28 VDD.t95 XM7.S VOUT.t46 VDD.t94 sky130_fd_pr__pfet_01v8_lvt ad=3.625 pd=25.29 as=3.625 ps=25.29 w=25 l=0.35
X29 VOUT.t45 XM7.S VDD.t73 VDD.t72 sky130_fd_pr__pfet_01v8_lvt ad=3.625 pd=25.29 as=3.625 ps=25.29 w=25 l=0.35
X30 VOUT.t44 XM7.S VDD.t75 VDD.t74 sky130_fd_pr__pfet_01v8_lvt ad=3.625 pd=25.29 as=3.625 ps=25.29 w=25 l=0.35
X31 XM7.S XM7.G GND.t8 GND.t7 sky130_fd_pr__nfet_01v8_lvt ad=1.508 pd=10.98 as=1.508 ps=10.98 w=5.2 l=0.25
X32 VOUT.t43 XM7.S VDD.t77 VDD.t76 sky130_fd_pr__pfet_01v8_lvt ad=3.625 pd=25.29 as=3.625 ps=25.29 w=25 l=0.35
X33 VOUT.t42 XM7.S VDD.t79 VDD.t78 sky130_fd_pr__pfet_01v8_lvt ad=3.625 pd=25.29 as=3.625 ps=25.29 w=25 l=0.35
X34 VOUT.t41 XM7.S VDD.t93 VDD.t92 sky130_fd_pr__pfet_01v8_lvt ad=3.625 pd=25.29 as=3.625 ps=25.29 w=25 l=0.35
X35 VDD.t91 XM7.S VOUT.t40 VDD.t90 sky130_fd_pr__pfet_01v8_lvt ad=3.625 pd=25.29 as=3.625 ps=25.29 w=25 l=0.35
X36 VDD.t89 XM7.S VOUT.t39 VDD.t88 sky130_fd_pr__pfet_01v8_lvt ad=7.25 pd=50.58 as=3.625 ps=25.29 w=25 l=0.35
X37 VDD.t81 XM7.S VOUT.t38 VDD.t80 sky130_fd_pr__pfet_01v8_lvt ad=3.625 pd=25.29 as=3.625 ps=25.29 w=25 l=0.35
X38 VOUT.t37 XM7.S VDD.t83 VDD.t82 sky130_fd_pr__pfet_01v8_lvt ad=3.625 pd=25.29 as=3.625 ps=25.29 w=25 l=0.35
X39 VOUT.t36 XM7.S VDD.t87 VDD.t86 sky130_fd_pr__pfet_01v8_lvt ad=3.625 pd=25.29 as=3.625 ps=25.29 w=25 l=0.35
X40 VDD.t85 XM7.S VOUT.t35 VDD.t84 sky130_fd_pr__pfet_01v8_lvt ad=3.625 pd=25.29 as=3.625 ps=25.29 w=25 l=0.35
X41 VDD.t71 XM7.S VOUT.t34 VDD.t70 sky130_fd_pr__pfet_01v8_lvt ad=3.625 pd=25.29 as=3.625 ps=25.29 w=25 l=0.35
X42 VDD.t151 XM14.D XM14.D VDD.t150 sky130_fd_pr__pfet_01v8_lvt ad=0.29 pd=2.58 as=0.29 ps=2.58 w=1 l=1
X43 VDD.t69 XM7.S VOUT.t33 VDD.t68 sky130_fd_pr__pfet_01v8_lvt ad=3.625 pd=25.29 as=3.625 ps=25.29 w=25 l=0.35
X44 VDD.t67 XM7.S VOUT.t32 VDD.t66 sky130_fd_pr__pfet_01v8_lvt ad=3.625 pd=25.29 as=3.625 ps=25.29 w=25 l=0.35
X45 XM7.G XM14.D VDD.t149 VDD.t148 sky130_fd_pr__pfet_01v8_lvt ad=0.29 pd=2.58 as=0.29 ps=2.58 w=1 l=1
X46 VDD.t3 XM1.D XM1.D VDD.t2 sky130_fd_pr__pfet_01v8_lvt ad=0.145 pd=1.58 as=0.145 ps=1.58 w=0.5 l=1
X47 XM2.S.t1 XR1.R2 XM1.S GND.t1 sky130_fd_pr__nfet_01v8_lvt ad=0.232 pd=2.18 as=0.232 ps=2.18 w=0.8 l=1
X48 VOUT.t31 XM7.S VDD.t65 VDD.t64 sky130_fd_pr__pfet_01v8_lvt ad=3.625 pd=25.29 as=3.625 ps=25.29 w=25 l=0.35
X49 VDD.t63 XM7.S VOUT.t30 VDD.t62 sky130_fd_pr__pfet_01v8_lvt ad=3.625 pd=25.29 as=3.625 ps=25.29 w=25 l=0.35
X50 VDD.t61 XM7.S VOUT.t29 VDD.t60 sky130_fd_pr__pfet_01v8_lvt ad=7.25 pd=50.58 as=3.625 ps=25.29 w=25 l=0.35
X51 XM2.S.t0 XM1.D VDD.t1 VDD.t0 sky130_fd_pr__pfet_01v8_lvt ad=0.145 pd=1.58 as=0.145 ps=1.58 w=0.5 l=1
X52 VOUT.t28 XM7.S VDD.t59 VDD.t58 sky130_fd_pr__pfet_01v8_lvt ad=3.625 pd=25.29 as=7.25 ps=50.58 w=25 l=0.35
X53 VDD.t53 XM7.S VOUT.t27 VDD.t52 sky130_fd_pr__pfet_01v8_lvt ad=7.25 pd=50.58 as=3.625 ps=25.29 w=25 l=0.35
X54 VOUT.t26 XM7.S VDD.t57 VDD.t56 sky130_fd_pr__pfet_01v8_lvt ad=3.625 pd=25.29 as=3.625 ps=25.29 w=25 l=0.35
X55 VDD.t147 XM14.D XM13.S VDD.t146 sky130_fd_pr__pfet_01v8_lvt ad=0.29 pd=2.58 as=0.29 ps=2.58 w=1 l=1
X56 VOUT.t25 XM7.S VDD.t55 VDD.t54 sky130_fd_pr__pfet_01v8_lvt ad=3.625 pd=25.29 as=3.625 ps=25.29 w=25 l=0.35
X57 VOUT.t24 XM7.S VDD.t51 VDD.t50 sky130_fd_pr__pfet_01v8_lvt ad=3.625 pd=25.29 as=3.625 ps=25.29 w=25 l=0.35
X58 VOUT.t23 XM7.S VDD.t49 VDD.t48 sky130_fd_pr__pfet_01v8_lvt ad=3.625 pd=25.29 as=3.625 ps=25.29 w=25 l=0.35
X59 VOUT.t22 XM7.S VDD.t47 VDD.t46 sky130_fd_pr__pfet_01v8_lvt ad=3.625 pd=25.29 as=3.625 ps=25.29 w=25 l=0.35
X60 XM13.S XM13.S GND.t3 GND.t2 sky130_fd_pr__nfet_01v8_lvt ad=0.58 pd=4.58 as=0.58 ps=4.58 w=2 l=1
X61 VOUT.t21 XM7.S VDD.t45 VDD.t44 sky130_fd_pr__pfet_01v8_lvt ad=3.625 pd=25.29 as=3.625 ps=25.29 w=25 l=0.35
X62 VOUT.t20 XM7.S VDD.t43 VDD.t42 sky130_fd_pr__pfet_01v8_lvt ad=3.625 pd=25.29 as=3.625 ps=25.29 w=25 l=0.35
X63 VOUT.t19 XM7.S VDD.t41 VDD.t40 sky130_fd_pr__pfet_01v8_lvt ad=3.625 pd=25.29 as=3.625 ps=25.29 w=25 l=0.35
X64 VDD.t39 XM7.S VOUT.t18 VDD.t38 sky130_fd_pr__pfet_01v8_lvt ad=3.625 pd=25.29 as=3.625 ps=25.29 w=25 l=0.35
X65 VDD.t35 XM7.S VOUT.t17 VDD.t34 sky130_fd_pr__pfet_01v8_lvt ad=7.25 pd=50.58 as=3.625 ps=25.29 w=25 l=0.35
X66 VOUT.t16 XM7.S VDD.t37 VDD.t36 sky130_fd_pr__pfet_01v8_lvt ad=3.625 pd=25.29 as=7.25 ps=50.58 w=25 l=0.35
X67 VOUT.t15 XM7.S VDD.t33 VDD.t32 sky130_fd_pr__pfet_01v8_lvt ad=3.625 pd=25.29 as=3.625 ps=25.29 w=25 l=0.35
X68 XM7.S XM2.S.t2 VDD.t145 VDD.t144 sky130_fd_pr__pfet_01v8_lvt ad=1.218 pd=8.98 as=1.218 ps=8.98 w=4.2 l=0.35
X69 XM1.S Vref.t0 XM1.D GND.t15 sky130_fd_pr__nfet_01v8_lvt ad=0.232 pd=2.18 as=0.232 ps=2.18 w=0.8 l=1
X70 VDD.t31 XM7.S VOUT.t14 VDD.t30 sky130_fd_pr__pfet_01v8_lvt ad=3.625 pd=25.29 as=3.625 ps=25.29 w=25 l=0.35
X71 VDD.t7 XM7.S VOUT.t13 VDD.t6 sky130_fd_pr__pfet_01v8_lvt ad=3.625 pd=25.29 as=3.625 ps=25.29 w=25 l=0.35
X72 VDD.t29 XM7.S VOUT.t12 VDD.t28 sky130_fd_pr__pfet_01v8_lvt ad=3.625 pd=25.29 as=3.625 ps=25.29 w=25 l=0.35
X73 VDD.t11 XM7.S VOUT.t11 VDD.t10 sky130_fd_pr__pfet_01v8_lvt ad=3.625 pd=25.29 as=3.625 ps=25.29 w=25 l=0.35
X74 VDD.t19 XM7.S VOUT.t10 VDD.t18 sky130_fd_pr__pfet_01v8_lvt ad=3.625 pd=25.29 as=3.625 ps=25.29 w=25 l=0.35
X75 VOUT.t9 XM7.S VDD.t27 VDD.t26 sky130_fd_pr__pfet_01v8_lvt ad=3.625 pd=25.29 as=3.625 ps=25.29 w=25 l=0.35
X76 VDD.t25 XM7.S VOUT.t8 VDD.t24 sky130_fd_pr__pfet_01v8_lvt ad=3.625 pd=25.29 as=3.625 ps=25.29 w=25 l=0.35
X77 VDD.t23 XM7.S VOUT.t7 VDD.t22 sky130_fd_pr__pfet_01v8_lvt ad=3.625 pd=25.29 as=3.625 ps=25.29 w=25 l=0.35
X78 VDD.t21 XM7.S VOUT.t6 VDD.t20 sky130_fd_pr__pfet_01v8_lvt ad=3.625 pd=25.29 as=3.625 ps=25.29 w=25 l=0.35
X79 VOUT.t5 XM7.S VDD.t17 VDD.t16 sky130_fd_pr__pfet_01v8_lvt ad=3.625 pd=25.29 as=7.25 ps=50.58 w=25 l=0.35
X80 GND.t14 XR2.R1 GND.t13 sky130_fd_pr__res_high_po_0p35 l=3.1
X81 GND.t6 XM7.G XM7.G GND.t5 sky130_fd_pr__nfet_01v8_lvt ad=0.348 pd=2.98 as=0.348 ps=2.98 w=1.2 l=1
X82 VOUT.t4 XM7.S VDD.t15 VDD.t14 sky130_fd_pr__pfet_01v8_lvt ad=3.625 pd=25.29 as=3.625 ps=25.29 w=25 l=0.35
X83 VOUT.t3 XM7.S VDD.t13 VDD.t12 sky130_fd_pr__pfet_01v8_lvt ad=3.625 pd=25.29 as=3.625 ps=25.29 w=25 l=0.35
X84 VOUT.t2 XM7.S VDD.t9 VDD.t8 sky130_fd_pr__pfet_01v8_lvt ad=3.625 pd=25.29 as=3.625 ps=25.29 w=25 l=0.35
X85 VOUT.t1 XM7.S VDD.t5 VDD.t4 sky130_fd_pr__pfet_01v8_lvt ad=3.625 pd=25.29 as=3.625 ps=25.29 w=25 l=0.35
X86 XM2.S.t3 XM7.S sky130_fd_pr__cap_mim_m3_1 l=30 w=30
R0 VDD.n178 VDD.n177 14430.3
R1 VDD.n207 VDD.n2 12914.1
R2 VDD.n207 VDD.n3 12914.1
R3 VDD.n209 VDD.n3 12914.1
R4 VDD.n209 VDD.n2 12914.1
R5 VDD.n18 VDD.n5 12914.1
R6 VDD.n23 VDD.n5 12914.1
R7 VDD.n23 VDD.n6 12914.1
R8 VDD.n18 VDD.n6 12914.1
R9 VDD.n194 VDD.n107 12914.1
R10 VDD.n128 VDD.n107 12914.1
R11 VDD.n194 VDD.n108 12914.1
R12 VDD.n128 VDD.n108 12914.1
R13 VDD.n198 VDD.n102 12914.1
R14 VDD.n198 VDD.n103 12914.1
R15 VDD.n106 VDD.n102 12914.1
R16 VDD.n106 VDD.n103 12914.1
R17 VDD.n13 VDD.n11 12914.1
R18 VDD.n13 VDD.n9 12914.1
R19 VDD.n15 VDD.n11 12914.1
R20 VDD.n15 VDD.n9 12914.1
R21 VDD.n147 VDD.n139 2636.47
R22 VDD.n144 VDD.n140 2636.47
R23 VDD.n181 VDD.n121 1736.47
R24 VDD.n123 VDD.n121 1736.47
R25 VDD.n181 VDD.n180 1736.47
R26 VDD.n186 VDD.n116 1736.47
R27 VDD.n183 VDD.n116 1736.47
R28 VDD.n186 VDD.n117 1736.47
R29 VDD.n183 VDD.n117 1736.47
R30 VDD.n190 VDD.n111 1736.47
R31 VDD.n190 VDD.n112 1736.47
R32 VDD.n189 VDD.n111 1736.47
R33 VDD.n189 VDD.n112 1736.47
R34 VDD.n153 VDD.n151 1560
R35 VDD.n155 VDD.n150 1560
R36 VDD.n155 VDD.n151 1560
R37 VDD.n158 VDD.n133 1560
R38 VDD.n158 VDD.n135 1560
R39 VDD.n157 VDD.n133 1560
R40 VDD.n157 VDD.n135 1560
R41 VDD VDD.t1 642.13
R42 VDD VDD.t3 642.13
R43 VDD.t0 VDD.n152 429.089
R44 VDD.t2 VDD.n136 429.089
R45 VDD.t2 VDD.n137 429.089
R46 VDD.t148 VDD.n113 361.834
R47 VDD.t148 VDD.n114 361.834
R48 VDD.n185 VDD.t150 361.834
R49 VDD.t150 VDD.n184 361.834
R50 VDD.t146 VDD.n118 361.834
R51 VDD.n154 VDD.n150 357.824
R52 VDD.n137 VDD.n113 337.693
R53 VDD.n123 VDD.n122 314.781
R54 VDD.n17 VDD.n8 277.928
R55 VDD.n17 VDD.n16 277.928
R56 VDD.n26 VDD.n25 277.719
R57 VDD.n24 VDD.n0 277.719
R58 VDD.n200 VDD.n100 273.445
R59 VDD.n100 VDD.n1 273.445
R60 VDD.n193 VDD.n101 256.873
R61 VDD.n193 VDD.n192 256.873
R62 VDD VDD.t147 223.565
R63 VDD VDD.t151 223.565
R64 VDD VDD.t149 223.565
R65 VDD.n152 VDD.n136 187.175
R66 VDD.n184 VDD.n118 157.838
R67 VDD.n173 VDD.n99 153.439
R68 VDD.n145 VDD.n139 134.153
R69 VDD.n146 VDD.n140 134.153
R70 VDD.n185 VDD.n114 134.013
R71 VDD VDD.n10 97.6289
R72 VDD.n12 VDD.n10 72.8669
R73 VDD.n149 VDD.n130 62.0093
R74 VDD.n144 VDD.n143 61.6672
R75 VDD VDD.n147 61.6672
R76 VDD.n177 VDD.n126 57.3359
R77 VDD.n145 VDD.n144 57.1922
R78 VDD.n147 VDD.n146 57.1922
R79 VDD VDD.t145 55.5517
R80 VDD.n159 VDD.n132 53.0603
R81 VDD.n151 VDD.n131 46.2505
R82 VDD.n152 VDD.n151 46.2505
R83 VDD.n133 VDD.n131 46.2505
R84 VDD.n136 VDD.n133 46.2505
R85 VDD.n135 VDD.n134 46.2505
R86 VDD.n137 VDD.n135 46.2505
R87 VDD.n150 VDD.n149 46.2505
R88 VDD.n160 VDD.n159 38.6617
R89 VDD VDD.n138 38.0161
R90 VDD.n189 VDD 37.0005
R91 VDD.t148 VDD.n189 37.0005
R92 VDD.n117 VDD 37.0005
R93 VDD.t150 VDD.n117 37.0005
R94 VDD.n180 VDD 37.0005
R95 VDD VDD.n155 37.0005
R96 VDD.n155 VDD.t0 37.0005
R97 VDD.n157 VDD 37.0005
R98 VDD.t2 VDD.n157 37.0005
R99 VDD.n153 VDD.n130 37.0005
R100 VDD.n159 VDD.n158 37.0005
R101 VDD.n158 VDD.t2 37.0005
R102 VDD.n191 VDD.n190 37.0005
R103 VDD.n190 VDD.t148 37.0005
R104 VDD.n169 VDD.n116 37.0005
R105 VDD.t150 VDD.n116 37.0005
R106 VDD.n124 VDD.n121 37.0005
R107 VDD.t146 VDD.n121 37.0005
R108 VDD.n128 VDD.t58 33.5307
R109 VDD.t60 VDD.n11 33.5307
R110 VDD.n142 VDD.n1 33.4197
R111 VDD.n143 VDD.n142 31.4056
R112 VDD.n21 VDD.t88 31.0965
R113 VDD.n104 VDD.t16 31.0965
R114 VDD.t120 VDD.n105 31.0965
R115 VDD.t122 VDD.n196 31.0965
R116 VDD.n195 VDD.t52 31.0965
R117 VDD.t36 VDD.n7 31.0965
R118 VDD.t34 VDD.n19 31.0965
R119 VDD.n22 VDD.t96 31.0965
R120 VDD.n179 VDD.n123 30.8386
R121 VDD.n187 VDD.n112 30.8338
R122 VDD.n114 VDD.n112 30.8338
R123 VDD.n183 VDD.n182 30.8338
R124 VDD.n184 VDD.n183 30.8338
R125 VDD.n187 VDD.n186 30.8338
R126 VDD.n186 VDD.n185 30.8338
R127 VDD.n182 VDD.n181 30.8338
R128 VDD.n181 VDD.n118 30.8338
R129 VDD.n132 VDD.n111 30.8338
R130 VDD.n113 VDD.n111 30.8338
R131 VDD.n180 VDD.n122 29.6618
R132 VDD.n177 VDD.n176 28.9704
R133 VDD.n154 VDD.n153 27.8536
R134 VDD.n161 VDD.n130 27.8209
R135 VDD.n187 VDD.n110 25.7037
R136 VDD.n188 VDD.n187 25.7037
R137 VDD.n16 VDD 25.4556
R138 VDD.n16 VDD 25.4556
R139 VDD VDD.n0 25.4501
R140 VDD VDD.n1 25.384
R141 VDD VDD.n0 25.3599
R142 VDD.n143 VDD.n138 24.4658
R143 VDD.n182 VDD.n119 22.7662
R144 VDD.n182 VDD.n120 22.7662
R145 VDD.t88 VDD.t126 22.3617
R146 VDD.t126 VDD.t94 22.3617
R147 VDD.t94 VDD.t108 22.3617
R148 VDD.t108 VDD.t138 22.3617
R149 VDD.t138 VDD.t26 22.3617
R150 VDD.t26 VDD.t90 22.3617
R151 VDD.t84 VDD.t56 22.3617
R152 VDD.t98 VDD.t84 22.3617
R153 VDD.t140 VDD.t98 22.3617
R154 VDD.t4 VDD.t140 22.3617
R155 VDD.t128 VDD.t4 22.3617
R156 VDD.t16 VDD.t128 22.3617
R157 VDD.t142 VDD.t120 22.3617
R158 VDD.t130 VDD.t142 22.3617
R159 VDD.t12 VDD.t130 22.3617
R160 VDD.t24 VDD.t12 22.3617
R161 VDD.t102 VDD.t24 22.3617
R162 VDD.t134 VDD.t102 22.3617
R163 VDD.t78 VDD.t114 22.3617
R164 VDD.t114 VDD.t14 22.3617
R165 VDD.t14 VDD.t28 22.3617
R166 VDD.t28 VDD.t40 22.3617
R167 VDD.t40 VDD.t18 22.3617
R168 VDD.t18 VDD.t122 22.3617
R169 VDD.t42 VDD.t52 22.3617
R170 VDD.t66 VDD.t42 22.3617
R171 VDD.t82 VDD.t66 22.3617
R172 VDD.t6 VDD.t82 22.3617
R173 VDD.t54 VDD.t6 22.3617
R174 VDD.t30 VDD.t54 22.3617
R175 VDD.t68 VDD.t44 22.3617
R176 VDD.t100 VDD.t68 22.3617
R177 VDD.t118 VDD.t100 22.3617
R178 VDD.t76 VDD.t118 22.3617
R179 VDD.t38 VDD.t76 22.3617
R180 VDD.t58 VDD.t38 22.3617
R181 VDD.t86 VDD.t60 22.3617
R182 VDD.t104 VDD.t86 22.3617
R183 VDD.t136 VDD.t104 22.3617
R184 VDD.t124 VDD.t136 22.3617
R185 VDD.t132 VDD.t124 22.3617
R186 VDD.t20 VDD.t132 22.3617
R187 VDD.t32 VDD.t106 22.3617
R188 VDD.t106 VDD.t92 22.3617
R189 VDD.t92 VDD.t116 22.3617
R190 VDD.t116 VDD.t8 22.3617
R191 VDD.t8 VDD.t22 22.3617
R192 VDD.t22 VDD.t36 22.3617
R193 VDD.t46 VDD.t34 22.3617
R194 VDD.t70 VDD.t46 22.3617
R195 VDD.t48 VDD.t70 22.3617
R196 VDD.t62 VDD.t48 22.3617
R197 VDD.t74 VDD.t62 22.3617
R198 VDD.t112 VDD.t74 22.3617
R199 VDD.t10 VDD.t64 22.3617
R200 VDD.t50 VDD.t10 22.3617
R201 VDD.t80 VDD.t50 22.3617
R202 VDD.t72 VDD.t80 22.3617
R203 VDD.t110 VDD.t72 22.3617
R204 VDD.t96 VDD.t110 22.3617
R205 VDD.n160 VDD.n131 18.1948
R206 VDD.n156 VDD.n131 18.1948
R207 VDD VDD.n115 17.944
R208 VDD VDD.n115 17.8477
R209 VDD.n196 VDD.n195 17.1208
R210 VDD.n105 VDD.n104 15.7232
R211 VDD.n120 VDD 15.5284
R212 VDD VDD.n120 15.5284
R213 VDD.n156 VDD 15.4021
R214 VDD VDD.n156 15.4021
R215 VDD.n44 VDD.t61 15.3954
R216 VDD.n19 VDD.n7 15.3738
R217 VDD.n22 VDD.n21 15.3732
R218 VDD.n92 VDD.t121 15.3304
R219 VDD.n59 VDD.t89 15.3304
R220 VDD.n84 VDD.t53 15.2565
R221 VDD.n51 VDD.t35 15.2389
R222 VDD VDD.n188 15.1087
R223 VDD.n188 VDD 15.1087
R224 VDD.n199 VDD.n101 14.6389
R225 VDD.n126 VDD.n101 14.6389
R226 VDD.n200 VDD.n199 14.5837
R227 VDD.n12 VDD.n8 14.5384
R228 VDD.n8 VDD.n4 14.5384
R229 VDD.n26 VDD.n4 14.5384
R230 VDD.n27 VDD.n26 14.5265
R231 VDD.n140 VDD.n138 12.3338
R232 VDD.n141 VDD.n139 12.3338
R233 VDD VDD.n148 11.7598
R234 VDD.n208 VDD.t90 11.1811
R235 VDD.n208 VDD.t56 11.1811
R236 VDD.n197 VDD.t134 11.1811
R237 VDD.n197 VDD.t78 11.1811
R238 VDD.n127 VDD.t30 11.1811
R239 VDD.t44 VDD.n127 11.1811
R240 VDD.n14 VDD.t20 11.1811
R241 VDD.n14 VDD.t32 11.1811
R242 VDD.n20 VDD.t112 11.1811
R243 VDD.t64 VDD.n20 11.1811
R244 VDD.n134 VDD.n115 10.886
R245 VDD.n161 VDD.n160 10.8413
R246 VDD.n149 VDD.n148 10.3045
R247 VDD.n148 VDD 9.3271
R248 VDD.n129 VDD 9.30175
R249 VDD.n129 VDD 9.30175
R250 VDD.n205 VDD.n204 9.3005
R251 VDD VDD.t59 9.1568
R252 VDD VDD.t123 9.1568
R253 VDD VDD.t17 9.1568
R254 VDD VDD.t97 9.1568
R255 VDD VDD.t37 9.1568
R256 VDD.n201 VDD.n200 9.06832
R257 VDD.n176 VDD.n125 8.53855
R258 VDD.t0 VDD.n154 8.48781
R259 VDD VDD.n179 8.26283
R260 VDD VDD.n77 8.0142
R261 VDD VDD.n76 8.0142
R262 VDD VDD.n75 8.0142
R263 VDD VDD.n74 8.0142
R264 VDD VDD.n73 8.0142
R265 VDD VDD.n72 8.0142
R266 VDD VDD.n71 8.0142
R267 VDD VDD.n70 8.0142
R268 VDD VDD.n69 8.0142
R269 VDD VDD.n68 8.0142
R270 VDD VDD.n67 8.0142
R271 VDD VDD.n66 8.0142
R272 VDD VDD.n65 8.0142
R273 VDD VDD.n64 8.0142
R274 VDD VDD.n63 8.0142
R275 VDD VDD.n29 8.0142
R276 VDD VDD.n30 8.0142
R277 VDD VDD.n31 8.0142
R278 VDD VDD.n32 8.0142
R279 VDD VDD.n33 8.0142
R280 VDD VDD.n34 8.0142
R281 VDD VDD.n35 8.0142
R282 VDD VDD.n36 8.0142
R283 VDD VDD.n37 8.0142
R284 VDD VDD.n38 8.0142
R285 VDD VDD.n39 8.0142
R286 VDD VDD.n40 8.0142
R287 VDD VDD.n41 8.0142
R288 VDD VDD.n42 8.0142
R289 VDD VDD.n43 8.0142
R290 VDD.n179 VDD.n178 7.03326
R291 VDD VDD.n106 6.85235
R292 VDD.n197 VDD.n106 6.85235
R293 VDD VDD.n108 6.85235
R294 VDD.n127 VDD.n108 6.85235
R295 VDD VDD.n15 6.85235
R296 VDD.n15 VDD.n14 6.85235
R297 VDD VDD.n6 6.85235
R298 VDD.n20 VDD.n6 6.85235
R299 VDD.n13 VDD.n12 6.85235
R300 VDD.n14 VDD.n13 6.85235
R301 VDD.n5 VDD.n4 6.85235
R302 VDD.n20 VDD.n5 6.85235
R303 VDD VDD.n209 6.85235
R304 VDD.n209 VDD.n208 6.85235
R305 VDD.n207 VDD.n206 6.85235
R306 VDD.n208 VDD.n207 6.85235
R307 VDD.n199 VDD.n198 6.85235
R308 VDD.n198 VDD.n197 6.85235
R309 VDD.n126 VDD.n107 6.85235
R310 VDD.n127 VDD.n107 6.85235
R311 VDD.n122 VDD.t146 6.70818
R312 VDD.n50 VDD 6.20181
R313 VDD.n49 VDD 6.20181
R314 VDD.n48 VDD 6.20181
R315 VDD.n47 VDD 6.20181
R316 VDD.n46 VDD 6.20181
R317 VDD.n45 VDD 6.20181
R318 VDD.n44 VDD 6.20181
R319 VDD.n85 VDD 6.17415
R320 VDD.n86 VDD 6.17415
R321 VDD.n87 VDD 6.17415
R322 VDD.n88 VDD 6.17415
R323 VDD.n89 VDD 6.17415
R324 VDD.n90 VDD 6.17415
R325 VDD.n91 VDD 6.17415
R326 VDD.n94 VDD 6.17415
R327 VDD.n95 VDD 6.17415
R328 VDD.n96 VDD 6.17415
R329 VDD.n62 VDD 6.17415
R330 VDD.n61 VDD 6.17415
R331 VDD.n60 VDD 6.17415
R332 VDD.n93 VDD 6.17332
R333 VDD.n78 VDD 6.13751
R334 VDD.n78 VDD 6.10022
R335 VDD.n79 VDD 6.10022
R336 VDD.n80 VDD 6.10022
R337 VDD.n81 VDD 6.10022
R338 VDD.n82 VDD 6.10022
R339 VDD.n83 VDD 6.10022
R340 VDD.n58 VDD 6.08264
R341 VDD.n57 VDD 6.08264
R342 VDD.n56 VDD 6.08264
R343 VDD.n55 VDD 6.08264
R344 VDD.n54 VDD 6.08264
R345 VDD.n53 VDD 6.08264
R346 VDD.n52 VDD 6.08264
R347 VDD.n205 VDD.n28 5.0735
R348 VDD.n172 VDD 4.90577
R349 VDD.n166 VDD 4.69819
R350 VDD.n166 VDD 4.69701
R351 VDD.n11 VDD.n10 3.38095
R352 VDD.n146 VDD.t144 3.13878
R353 VDD.t144 VDD.n145 3.13878
R354 VDD.n134 VDD.n132 2.62614
R355 VDD.n192 VDD.n191 2.44351
R356 VDD.n193 VDD.n103 2.43471
R357 VDD.n196 VDD.n103 2.43471
R358 VDD.n177 VDD.n128 2.43471
R359 VDD.n194 VDD.n193 2.43471
R360 VDD.n195 VDD.n194 2.43471
R361 VDD.n17 VDD.n9 2.43471
R362 VDD.n9 VDD.n7 2.43471
R363 VDD.n18 VDD.n17 2.43471
R364 VDD.n19 VDD.n18 2.43471
R365 VDD.n24 VDD.n23 2.43471
R366 VDD.n23 VDD.n22 2.43471
R367 VDD.n25 VDD.n2 2.43471
R368 VDD.n21 VDD.n2 2.43471
R369 VDD.n100 VDD.n3 2.43471
R370 VDD.n104 VDD.n3 2.43471
R371 VDD.n102 VDD.n100 2.43471
R372 VDD.n105 VDD.n102 2.43471
R373 VDD.n162 VDD.n161 2.36093
R374 VDD.n125 VDD.n124 2.15448
R375 VDD.n202 VDD.n99 1.49216
R376 VDD.n171 VDD.n170 1.163
R377 VDD.n77 VDD.t77 1.1431
R378 VDD.n77 VDD.t39 1.1431
R379 VDD.n76 VDD.t101 1.1431
R380 VDD.n76 VDD.t119 1.1431
R381 VDD.n75 VDD.t45 1.1431
R382 VDD.n75 VDD.t69 1.1431
R383 VDD.n74 VDD.t55 1.1431
R384 VDD.n74 VDD.t31 1.1431
R385 VDD.n73 VDD.t83 1.1431
R386 VDD.n73 VDD.t7 1.1431
R387 VDD.n72 VDD.t43 1.1431
R388 VDD.n72 VDD.t67 1.1431
R389 VDD.n71 VDD.t41 1.1431
R390 VDD.n71 VDD.t19 1.1431
R391 VDD.n70 VDD.t15 1.1431
R392 VDD.n70 VDD.t29 1.1431
R393 VDD.n69 VDD.t79 1.1431
R394 VDD.n69 VDD.t115 1.1431
R395 VDD.n68 VDD.t103 1.1431
R396 VDD.n68 VDD.t135 1.1431
R397 VDD.n67 VDD.t13 1.1431
R398 VDD.n67 VDD.t25 1.1431
R399 VDD.n66 VDD.t143 1.1431
R400 VDD.n66 VDD.t131 1.1431
R401 VDD.n65 VDD.t5 1.1431
R402 VDD.n65 VDD.t129 1.1431
R403 VDD.n64 VDD.t99 1.1431
R404 VDD.n64 VDD.t141 1.1431
R405 VDD.n63 VDD.t57 1.1431
R406 VDD.n63 VDD.t85 1.1431
R407 VDD.n29 VDD.t27 1.1431
R408 VDD.n29 VDD.t91 1.1431
R409 VDD.n30 VDD.t109 1.1431
R410 VDD.n30 VDD.t139 1.1431
R411 VDD.n31 VDD.t127 1.1431
R412 VDD.n31 VDD.t95 1.1431
R413 VDD.n32 VDD.t73 1.1431
R414 VDD.n32 VDD.t111 1.1431
R415 VDD.n33 VDD.t51 1.1431
R416 VDD.n33 VDD.t81 1.1431
R417 VDD.n34 VDD.t65 1.1431
R418 VDD.n34 VDD.t11 1.1431
R419 VDD.n35 VDD.t75 1.1431
R420 VDD.n35 VDD.t113 1.1431
R421 VDD.n36 VDD.t49 1.1431
R422 VDD.n36 VDD.t63 1.1431
R423 VDD.n37 VDD.t47 1.1431
R424 VDD.n37 VDD.t71 1.1431
R425 VDD.n38 VDD.t9 1.1431
R426 VDD.n38 VDD.t23 1.1431
R427 VDD.n39 VDD.t93 1.1431
R428 VDD.n39 VDD.t117 1.1431
R429 VDD.n40 VDD.t33 1.1431
R430 VDD.n40 VDD.t107 1.1431
R431 VDD.n41 VDD.t133 1.1431
R432 VDD.n41 VDD.t21 1.1431
R433 VDD.n42 VDD.t137 1.1431
R434 VDD.n42 VDD.t125 1.1431
R435 VDD.n43 VDD.t87 1.1431
R436 VDD.n43 VDD.t105 1.1431
R437 VDD.n124 VDD.n119 1.01899
R438 VDD.n170 VDD.n169 1.01555
R439 VDD.n191 VDD.n110 0.991468
R440 VDD.n192 VDD.n109 0.908887
R441 VDD.n163 VDD 0.846475
R442 VDD.n169 VDD 0.781575
R443 VDD.n168 VDD.n167 0.7755
R444 VDD.n165 VDD.n109 0.7755
R445 VDD.n175 VDD.n174 0.640494
R446 VDD.n201 VDD.n28 0.415187
R447 VDD.n141 VDD 0.406522
R448 VDD.n166 VDD.n165 0.402286
R449 VDD.n164 VDD.n163 0.341588
R450 VDD.n161 VDD.n109 0.313618
R451 VDD.n163 VDD.n162 0.287074
R452 VDD.n25 VDD.n24 0.210336
R453 VDD VDD.n168 0.189747
R454 VDD.n171 VDD.n167 0.184492
R455 VDD.n174 VDD.n172 0.155474
R456 VDD.n164 VDD.n129 0.139431
R457 VDD.n174 VDD.n173 0.106251
R458 VDD.n178 VDD.n125 0.0899624
R459 VDD.n173 VDD 0.0742132
R460 VDD.n162 VDD 0.0624355
R461 VDD.n142 VDD.n141 0.0589946
R462 VDD.n204 VDD.n203 0.0545979
R463 VDD.n85 VDD.n84 0.0479942
R464 VDD.n59 VDD.n58 0.04712
R465 VDD.n93 VDD.n92 0.0468287
R466 VDD.n51 VDD.n50 0.0462459
R467 VDD.n206 VDD.n27 0.0419687
R468 VDD.n175 VDD.n99 0.0402727
R469 VDD.n45 VDD.n44 0.037796
R470 VDD.n46 VDD.n45 0.037796
R471 VDD.n47 VDD.n46 0.037796
R472 VDD.n48 VDD.n47 0.037796
R473 VDD.n49 VDD.n48 0.037796
R474 VDD.n50 VDD.n49 0.037796
R475 VDD.n52 VDD.n51 0.037796
R476 VDD.n53 VDD.n52 0.037796
R477 VDD.n54 VDD.n53 0.037796
R478 VDD.n55 VDD.n54 0.037796
R479 VDD.n56 VDD.n55 0.037796
R480 VDD.n57 VDD.n56 0.037796
R481 VDD.n58 VDD.n57 0.037796
R482 VDD.n60 VDD.n59 0.037796
R483 VDD.n61 VDD.n60 0.037796
R484 VDD.n62 VDD.n61 0.037796
R485 VDD.n96 VDD.n95 0.037796
R486 VDD.n95 VDD.n94 0.037796
R487 VDD.n94 VDD.n93 0.037796
R488 VDD.n92 VDD.n91 0.037796
R489 VDD.n91 VDD.n90 0.037796
R490 VDD.n90 VDD.n89 0.037796
R491 VDD.n89 VDD.n88 0.037796
R492 VDD.n88 VDD.n87 0.037796
R493 VDD.n87 VDD.n86 0.037796
R494 VDD.n86 VDD.n85 0.037796
R495 VDD.n84 VDD.n83 0.037796
R496 VDD.n83 VDD.n82 0.037796
R497 VDD.n82 VDD.n81 0.037796
R498 VDD.n81 VDD.n80 0.037796
R499 VDD.n80 VDD.n79 0.037796
R500 VDD.n79 VDD.n78 0.037796
R501 VDD.n172 VDD.n171 0.0314311
R502 VDD.n206 VDD.n205 0.0281458
R503 VDD.n168 VDD.n110 0.0211452
R504 VDD.n203 VDD.n28 0.0205
R505 VDD.n97 VDD.n96 0.0201856
R506 VDD.n97 VDD.n62 0.019103
R507 VDD.n98 VDD.n27 0.0166458
R508 VDD.n202 VDD.n201 0.0155974
R509 VDD.n176 VDD.n175 0.0121541
R510 VDD.n203 VDD.n202 0.00492217
R511 VDD.n170 VDD.n119 0.00394086
R512 VDD.n98 VDD.n97 0.00349826
R513 VDD.n165 VDD.n164 0.00305102
R514 VDD.n167 VDD.n166 0.00305102
R515 VDD.n204 VDD.n98 0.00123703
R516 VOUT.n0 VOUT.t0 40.8142
R517 VOUT.n0 VOUT 33.275
R518 VOUT VOUT.n1 8.0142
R519 VOUT VOUT.n2 8.0142
R520 VOUT VOUT.n3 8.0142
R521 VOUT VOUT.n4 8.0142
R522 VOUT VOUT.n5 8.0142
R523 VOUT VOUT.n6 8.0142
R524 VOUT VOUT.n7 8.0142
R525 VOUT VOUT.n8 8.0142
R526 VOUT VOUT.n9 8.0142
R527 VOUT VOUT.n10 8.0142
R528 VOUT VOUT.n11 8.0142
R529 VOUT VOUT.n12 8.0142
R530 VOUT VOUT.n13 8.0142
R531 VOUT VOUT.n14 8.0142
R532 VOUT VOUT.n15 8.0142
R533 VOUT VOUT.n16 8.0142
R534 VOUT VOUT.n17 8.0142
R535 VOUT VOUT.n18 8.0142
R536 VOUT VOUT.n19 8.0142
R537 VOUT VOUT.n20 8.0142
R538 VOUT VOUT.n21 8.0142
R539 VOUT VOUT.n22 8.0142
R540 VOUT VOUT.n23 8.0142
R541 VOUT VOUT.n24 8.0142
R542 VOUT VOUT.n58 8.0142
R543 VOUT VOUT.n57 8.0142
R544 VOUT VOUT.n56 8.0142
R545 VOUT VOUT.n55 8.0142
R546 VOUT VOUT.n54 8.0142
R547 VOUT VOUT.n53 8.0142
R548 VOUT VOUT.n52 8.0142
R549 VOUT VOUT.n51 8.0142
R550 VOUT VOUT.n50 8.0142
R551 VOUT VOUT.n49 8.0142
R552 VOUT VOUT.n48 8.0142
R553 VOUT.n25 VOUT 6.62696
R554 VOUT.n30 VOUT 6.60942
R555 VOUT.n29 VOUT 6.60942
R556 VOUT.n28 VOUT 6.60942
R557 VOUT.n27 VOUT 6.60942
R558 VOUT.n26 VOUT 6.60942
R559 VOUT.n25 VOUT 6.60942
R560 VOUT.n44 VOUT 6.50621
R561 VOUT.n43 VOUT 6.50621
R562 VOUT.n42 VOUT 6.50621
R563 VOUT.n41 VOUT 6.50621
R564 VOUT.n40 VOUT 6.50621
R565 VOUT.n39 VOUT 6.50621
R566 VOUT.n38 VOUT 6.50621
R567 VOUT.n37 VOUT 6.50621
R568 VOUT.n36 VOUT 6.50621
R569 VOUT.n35 VOUT 6.50621
R570 VOUT.n34 VOUT 6.50621
R571 VOUT.n33 VOUT 6.50621
R572 VOUT.n32 VOUT 6.50621
R573 VOUT.n31 VOUT 6.50621
R574 VOUT.n59 VOUT 6.4974
R575 VOUT.n59 VOUT 6.4974
R576 VOUT.n59 VOUT 6.4974
R577 VOUT.n59 VOUT 6.4974
R578 VOUT.n59 VOUT 6.4974
R579 VOUT.n59 VOUT 6.4974
R580 VOUT.n59 VOUT 6.4974
R581 VOUT.n47 VOUT 6.47805
R582 VOUT.n46 VOUT 6.47805
R583 VOUT.n45 VOUT 6.47805
R584 VOUT.n59 VOUT 6.47805
R585 VOUT.n59 VOUT 6.47805
R586 VOUT.n59 VOUT 6.47805
R587 VOUT.n59 VOUT 6.47805
R588 VOUT.n61 VOUT.n0 1.87819
R589 VOUT.n1 VOUT.t11 1.1431
R590 VOUT.n1 VOUT.t24 1.1431
R591 VOUT.n2 VOUT.t38 1.1431
R592 VOUT.n2 VOUT.t45 1.1431
R593 VOUT.n3 VOUT.t63 1.1431
R594 VOUT.n3 VOUT.t47 1.1431
R595 VOUT.n4 VOUT.t39 1.1431
R596 VOUT.n4 VOUT.t58 1.1431
R597 VOUT.n5 VOUT.t46 1.1431
R598 VOUT.n5 VOUT.t64 1.1431
R599 VOUT.n6 VOUT.t67 1.1431
R600 VOUT.n6 VOUT.t9 1.1431
R601 VOUT.n7 VOUT.t40 1.1431
R602 VOUT.n7 VOUT.t26 1.1431
R603 VOUT.n8 VOUT.t35 1.1431
R604 VOUT.n8 VOUT.t50 1.1431
R605 VOUT.n9 VOUT.t68 1.1431
R606 VOUT.n9 VOUT.t1 1.1431
R607 VOUT.n10 VOUT.t59 1.1431
R608 VOUT.n10 VOUT.t5 1.1431
R609 VOUT.n11 VOUT.t53 1.1431
R610 VOUT.n11 VOUT.t70 1.1431
R611 VOUT.n12 VOUT.t60 1.1431
R612 VOUT.n12 VOUT.t3 1.1431
R613 VOUT.n13 VOUT.t8 1.1431
R614 VOUT.n13 VOUT.t48 1.1431
R615 VOUT.n14 VOUT.t66 1.1431
R616 VOUT.n14 VOUT.t42 1.1431
R617 VOUT.n15 VOUT.t61 1.1431
R618 VOUT.n15 VOUT.t4 1.1431
R619 VOUT.n16 VOUT.t12 1.1431
R620 VOUT.n16 VOUT.t19 1.1431
R621 VOUT.n17 VOUT.t10 1.1431
R622 VOUT.n17 VOUT.t54 1.1431
R623 VOUT.n18 VOUT.t27 1.1431
R624 VOUT.n18 VOUT.t20 1.1431
R625 VOUT.n19 VOUT.t32 1.1431
R626 VOUT.n19 VOUT.t37 1.1431
R627 VOUT.n20 VOUT.t13 1.1431
R628 VOUT.n20 VOUT.t25 1.1431
R629 VOUT.n21 VOUT.t14 1.1431
R630 VOUT.n21 VOUT.t21 1.1431
R631 VOUT.n22 VOUT.t33 1.1431
R632 VOUT.n22 VOUT.t49 1.1431
R633 VOUT.n23 VOUT.t56 1.1431
R634 VOUT.n23 VOUT.t43 1.1431
R635 VOUT.n24 VOUT.t18 1.1431
R636 VOUT.n24 VOUT.t28 1.1431
R637 VOUT.n58 VOUT.t51 1.1431
R638 VOUT.n58 VOUT.t69 1.1431
R639 VOUT.n57 VOUT.t6 1.1431
R640 VOUT.n57 VOUT.t15 1.1431
R641 VOUT.n56 VOUT.t57 1.1431
R642 VOUT.n56 VOUT.t2 1.1431
R643 VOUT.n55 VOUT.t17 1.1431
R644 VOUT.n55 VOUT.t22 1.1431
R645 VOUT.n54 VOUT.t30 1.1431
R646 VOUT.n54 VOUT.t44 1.1431
R647 VOUT.n53 VOUT.t62 1.1431
R648 VOUT.n53 VOUT.t31 1.1431
R649 VOUT.n52 VOUT.t34 1.1431
R650 VOUT.n52 VOUT.t23 1.1431
R651 VOUT.n51 VOUT.t7 1.1431
R652 VOUT.n51 VOUT.t16 1.1431
R653 VOUT.n50 VOUT.t52 1.1431
R654 VOUT.n50 VOUT.t41 1.1431
R655 VOUT.n49 VOUT.t55 1.1431
R656 VOUT.n49 VOUT.t65 1.1431
R657 VOUT.n48 VOUT.t29 1.1431
R658 VOUT.n48 VOUT.t36 1.1431
R659 VOUT.n61 VOUT.n60 0.269042
R660 VOUT VOUT.n61 0.245093
R661 VOUT.n31 VOUT.n30 0.0403849
R662 VOUT.n38 VOUT.n37 0.0399737
R663 VOUT.n45 VOUT.n44 0.0398366
R664 VOUT.n60 VOUT.n59 0.0377063
R665 VOUT.n47 VOUT.n46 0.0180439
R666 VOUT.n46 VOUT.n45 0.0180439
R667 VOUT.n44 VOUT.n43 0.0180439
R668 VOUT.n43 VOUT.n42 0.0180439
R669 VOUT.n42 VOUT.n41 0.0180439
R670 VOUT.n41 VOUT.n40 0.0180439
R671 VOUT.n40 VOUT.n39 0.0180439
R672 VOUT.n39 VOUT.n38 0.0180439
R673 VOUT.n37 VOUT.n36 0.0180439
R674 VOUT.n36 VOUT.n35 0.0180439
R675 VOUT.n35 VOUT.n34 0.0180439
R676 VOUT.n34 VOUT.n33 0.0180439
R677 VOUT.n33 VOUT.n32 0.0180439
R678 VOUT.n32 VOUT.n31 0.0180439
R679 VOUT.n30 VOUT.n29 0.0180439
R680 VOUT.n29 VOUT.n28 0.0180439
R681 VOUT.n28 VOUT.n27 0.0180439
R682 VOUT.n27 VOUT.n26 0.0180439
R683 VOUT.n26 VOUT.n25 0.0180439
R684 VOUT.n60 VOUT.n47 0.0140005
R685 GND.n115 GND.n14 2.90498e+06
R686 GND.n114 GND.n113 1.30939e+06
R687 GND.n37 GND.n5 89970.1
R688 GND.n38 GND.n2 35054.4
R689 GND.n124 GND.n2 35054.4
R690 GND.n124 GND.n3 35054.4
R691 GND.n38 GND.n3 35054.4
R692 GND.n12 GND.n11 24509.1
R693 GND.n117 GND.n12 24509.1
R694 GND.n118 GND.n11 24509.1
R695 GND.n118 GND.n117 24509.1
R696 GND.n67 GND.n6 5620.29
R697 GND.n121 GND.n6 5620.29
R698 GND.n121 GND.n7 5620.29
R699 GND.n67 GND.n7 5620.29
R700 GND.n44 GND.n31 4797.53
R701 GND.n44 GND.n32 4797.53
R702 GND.n57 GND.n31 4797.53
R703 GND.n57 GND.n32 4797.53
R704 GND.n114 GND.n5 3962.46
R705 GND.n99 GND.n73 3493.85
R706 GND.n99 GND.n74 3493.85
R707 GND.n96 GND.n73 3493.85
R708 GND.n96 GND.n74 3493.85
R709 GND.n91 GND.n82 3377.97
R710 GND.n92 GND.n82 3377.97
R711 GND.n92 GND.n81 3377.97
R712 GND.n91 GND.n81 3377.97
R713 GND.n106 GND.n24 2914.44
R714 GND.n106 GND.n25 2914.44
R715 GND.n68 GND.n24 2914.44
R716 GND.n68 GND.n25 2914.44
R717 GND.n61 GND.n28 2914.44
R718 GND.n62 GND.n61 2914.44
R719 GND.n63 GND.n28 2914.44
R720 GND.n63 GND.n62 2914.44
R721 GND.n109 GND.n22 2682.68
R722 GND.n109 GND.n23 2682.68
R723 GND.n75 GND.n22 2682.68
R724 GND.n75 GND.n23 2682.68
R725 GND.n54 GND.n18 2682.68
R726 GND.n111 GND.n18 2682.68
R727 GND.n54 GND.n19 2682.68
R728 GND.n111 GND.n19 2682.68
R729 GND.n122 GND.n5 2376.9
R730 GND.n37 GND.n36 1649.49
R731 GND.n36 GND.t11 1161.34
R732 GND.n115 GND.n114 945.14
R733 GND.t0 GND.n15 662.366
R734 GND.n78 GND.n77 514.516
R735 GND.n38 GND.n37 482.086
R736 GND.n83 GND.n4 388.351
R737 GND.n56 GND.n55 311.471
R738 GND.n103 GND.n67 307.967
R739 GND.n39 GND.n38 299.829
R740 GND.n42 GND.n41 299.062
R741 GND.n40 GND.n12 292.5
R742 GND.n36 GND.n12 292.5
R743 GND.n78 GND.n67 292.5
R744 GND.n121 GND 292.5
R745 GND.n122 GND.n121 292.5
R746 GND GND.n118 292.5
R747 GND.n118 GND.n4 292.5
R748 GND GND.n124 292.5
R749 GND.n124 GND.n123 292.5
R750 GND.t0 GND.n14 276.127
R751 GND.n98 GND.t4 239.517
R752 GND.t4 GND.n97 239.517
R753 GND.t2 GND.n83 239.517
R754 GND.n107 GND.t15 235.573
R755 GND.n76 GND.t5 235.573
R756 GND.n33 GND.t1 227.689
R757 GND.t13 GND.n79 225.718
R758 GND GND.n32 195
R759 GND.n32 GND.t7 195
R760 GND.n46 GND.n31 195
R761 GND.t7 GND.n31 195
R762 GND.t11 GND.n14 176.082
R763 GND.n123 GND.n122 173.477
R764 GND.t7 GND.n16 166.188
R765 GND.t7 GND.n15 151.35
R766 GND.n13 GND.n1 144.136
R767 GND.n116 GND.n16 139.478
R768 GND.n113 GND.t9 120.251
R769 GND GND.n63 117.001
R770 GND.n63 GND.t9 117.001
R771 GND.n61 GND.n60 117.001
R772 GND.n61 GND.t9 117.001
R773 GND GND.n25 117.001
R774 GND.t5 GND.n25 117.001
R775 GND.n71 GND.n24 117.001
R776 GND.t5 GND.n24 117.001
R777 GND.n111 GND.n110 117.001
R778 GND.n112 GND.n111 117.001
R779 GND GND.n19 117.001
R780 GND.t1 GND.n19 117.001
R781 GND.n54 GND.n53 117.001
R782 GND.n55 GND.n54 117.001
R783 GND.n34 GND.n18 117.001
R784 GND.t1 GND.n18 117.001
R785 GND.n74 GND 117.001
R786 GND.t4 GND.n74 117.001
R787 GND GND.n23 117.001
R788 GND.t15 GND.n23 117.001
R789 GND.n110 GND.n109 117.001
R790 GND.n109 GND.n108 117.001
R791 GND.n84 GND.n22 117.001
R792 GND.t15 GND.n22 117.001
R793 GND.n75 GND.n72 117.001
R794 GND.n76 GND.n75 117.001
R795 GND.n86 GND.n73 117.001
R796 GND.t4 GND.n73 117.001
R797 GND.n91 GND.n90 117.001
R798 GND.t2 GND.n91 117.001
R799 GND GND.n92 117.001
R800 GND.n92 GND.t2 117.001
R801 GND.n103 GND.n68 108.49
R802 GND.n113 GND.n112 107.438
R803 GND.n97 GND.n79 104.481
R804 GND.n62 GND.n26 97.5005
R805 GND.n62 GND.n17 97.5005
R806 GND.n30 GND.n28 97.5005
R807 GND.n33 GND.n28 97.5005
R808 GND.n106 GND.n105 97.5005
R809 GND.n107 GND.n106 97.5005
R810 GND.n77 GND.n68 97.5005
R811 GND.n108 GND.n17 94.6242
R812 GND.n39 GND.n0 88.8829
R813 GND.n126 GND.n125 86.0856
R814 GND.n41 GND.n35 79.9653
R815 GND GND.t10 76.1672
R816 GND GND.t6 76.1672
R817 GND.n81 GND.n80 73.1255
R818 GND.n81 GND.n79 73.1255
R819 GND.n88 GND.n82 73.1255
R820 GND.n83 GND.n82 73.1255
R821 GND.t0 GND.n116 70.3844
R822 GND.n100 GND.n99 65.0005
R823 GND.n99 GND.n98 65.0005
R824 GND.n96 GND.n95 65.0005
R825 GND.n97 GND.n96 65.0005
R826 GND.n35 GND.n13 63.5785
R827 GND.n120 GND.n119 55.9766
R828 GND.n40 GND.n39 55.5849
R829 GND.n64 GND.t14 41.0016
R830 GND.n128 GND.t12 40.8142
R831 GND GND.t3 39.5338
R832 GND GND.n120 38.5915
R833 GND GND.n128 33.275
R834 GND.n64 GND 33.0976
R835 GND.n45 GND.n44 32.5005
R836 GND.n44 GND.n16 32.5005
R837 GND.n58 GND.n57 32.5005
R838 GND.n57 GND.n56 32.5005
R839 GND.n46 GND.n45 31.2686
R840 GND.n87 GND.n80 30.3548
R841 GND.n95 GND.n94 29.0748
R842 GND.n93 GND.n6 26.5914
R843 GND.t13 GND.n6 26.5914
R844 GND.n66 GND.n7 26.5914
R845 GND.t13 GND.n7 26.5914
R846 GND.n103 GND.n66 25.2816
R847 GND.n84 GND.n21 25.0034
R848 GND.n34 GND.n21 24.904
R849 GND.n69 GND.n26 24.2829
R850 GND.n105 GND.n104 24.2829
R851 GND.n102 GND 22.9599
R852 GND.n90 GND.n89 21.2834
R853 GND.n85 GND.n84 19.7186
R854 GND.n110 GND.n20 19.6342
R855 GND.n110 GND.n21 19.4482
R856 GND.n47 GND.n34 19.0686
R857 GND.n98 GND.n78 17.7424
R858 GND.n87 GND.n86 17.7052
R859 GND.n90 GND.n87 17.7052
R860 GND.n45 GND.n43 16.7624
R861 GND GND.t8 15.68
R862 GND.n56 GND.n15 14.7854
R863 GND.t2 GND.t13 13.7998
R864 GND.n94 GND 13.7848
R865 GND.n86 GND.n85 13.5183
R866 GND.n47 GND.n46 12.5511
R867 GND.n60 GND.n20 12.2792
R868 GND GND.n9 11.9776
R869 GND.n55 GND.n33 11.8285
R870 GND.t1 GND.t9 11.8285
R871 GND.n112 GND.n17 11.8285
R872 GND.n123 GND.n4 11.8285
R873 GND.n58 GND.n30 11.8104
R874 GND.n94 GND.n93 11.72
R875 GND.n66 GND.n65 11.5346
R876 GND.n53 GND.n29 11.3346
R877 GND GND.n8 11.0644
R878 GND GND.n103 10.8978
R879 GND GND.n8 10.6141
R880 GND.n52 GND.n47 9.87479
R881 GND.n43 GND 9.7702
R882 GND.n101 GND.n71 9.53607
R883 GND.n116 GND.n115 9.52431
R884 GND.n52 GND.n51 9.40011
R885 GND GND.n59 9.25455
R886 GND.n48 GND.n27 9.05243
R887 GND GND.n27 8.77087
R888 GND GND.n70 8.63406
R889 GND GND.n27 7.56144
R890 GND.n65 GND.n10 7.17413
R891 GND.n119 GND 7.10294
R892 GND.n88 GND.n8 6.92284
R893 GND.n125 GND 6.88905
R894 GND.n104 GND 6.35231
R895 GND.n104 GND 6.29276
R896 GND.n85 GND.n72 5.86901
R897 GND.n70 GND 5.72232
R898 GND.n125 GND.n1 5.69097
R899 GND GND.n10 5.1127
R900 GND.n117 GND.n13 4.95813
R901 GND.n117 GND.t0 4.95813
R902 GND.n42 GND.n11 4.95813
R903 GND.t0 GND.n11 4.95813
R904 GND.n100 GND.n72 4.34098
R905 GND.n119 GND.n1 4.09653
R906 GND.n108 GND.n107 3.94315
R907 GND.t5 GND.t15 3.94315
R908 GND.n77 GND.n76 3.94315
R909 GND.n101 GND.n100 3.83164
R910 GND.n70 GND.n69 3.82332
R911 GND.n35 GND.n2 3.40166
R912 GND.t11 GND.n2 3.40166
R913 GND.n3 GND.n0 3.40166
R914 GND.t11 GND.n3 3.40166
R915 GND.n102 GND.n101 3.30015
R916 GND.n49 GND 3.17993
R917 GND.n43 GND.n42 2.81262
R918 GND.n126 GND.n0 2.66595
R919 GND.n128 GND.n127 2.63398
R920 GND.n59 GND.n58 2.61707
R921 GND.n89 GND 2.55047
R922 GND.n10 GND.n9 2.20416
R923 GND.n65 GND.n64 2.1061
R924 GND.n95 GND.n80 2.01193
R925 GND.n59 GND.n29 1.94525
R926 GND.n120 GND.n9 1.64153
R927 GND.n127 GND 1.17962
R928 GND.n53 GND.n52 0.914786
R929 GND.n49 GND.n48 0.776763
R930 GND.n50 GND 0.664786
R931 GND.n93 GND 0.582318
R932 GND.n60 GND 0.519419
R933 GND.n51 GND.n29 0.517167
R934 GND.n103 GND.n102 0.379447
R935 GND.n69 GND.n20 0.299631
R936 GND.n41 GND.n40 0.250615
R937 GND.n105 GND.n26 0.188735
R938 GND.n71 GND 0.172312
R939 GND.n48 GND.n30 0.141936
R940 GND.n50 GND.n49 0.105929
R941 GND.n51 GND.n50 0.0412197
R942 GND.n89 GND.n88 0.0182285
R943 GND.n127 GND.n126 0.00989394
R944 XM2.S XM2.S.t0 642.13
R945 XM2.S.n1 XM2.S.t2 494.752
R946 XM2.S.t2 XM2.S 485.269
R947 XM2.S XM2.S.t1 114.251
R948 XM2.S XM2.S.n1 9.54833
R949 XM2.S.n0 XM2.S 5.12271
R950 XM2.S.n1 XM2.S.n0 3.76022
R951 XM2.S.n0 XM2.S 0.841482
R952 XM2.S XM2.S.t3 0.00132177
R953 Vref Vref.t0 108.535
C0 VDD XR1.R2 0.29041f
C1 XR2.R1 XM7.G 0.49406f
C2 Vref VDD 0.01434f
C3 VOUT VDD 0.36261p
C4 XM13.S XM14.D 0.93535f
C5 XR1.R2 XM7.S 0.00292f
C6 XM2.S XM14.D 0
C7 Vref XM7.S 0
C8 VOUT XM7.S 92.9029f
C9 XM1.S VDD 0.00139f
C10 XM7.G VDD 0.56635f
C11 XM13.S XR2.R1 0.14642f
C12 XR2.R1 XM14.D 0.13352f
C13 XM7.G XM7.S 0.12435f
C14 XM1.D XR1.R2 0.35554f
C15 Vref XM1.D 0.48956f
C16 XM13.S VDD 1.12049f
C17 VDD XM14.D 3.67999f
C18 XM1.S XM1.D 0.06438f
C19 XM2.S VDD 1.93774f
C20 XM1.D XM7.G 0.72004f
C21 XM2.S XM7.S 80.6543f
C22 Vref XR1.R2 1.72875f
C23 XR2.R1 VDD 0
C24 XM1.S XR1.R2 0.06512f
C25 XM13.S XM1.D 0
C26 XM1.D XM14.D 0.0053f
C27 XM7.G XR1.R2 0.27437f
C28 Vref XM1.S 0.03575f
C29 XM2.S XM1.D 0.17913f
C30 Vref XM7.G 0.32834f
C31 VDD XM7.S 64.6638f
C32 XM1.S XM7.G 0.14649f
C33 XM13.S XR1.R2 0.83701f
C34 XR1.R2 XM14.D 0.39884f
C35 XM2.S XR1.R2 0.43218f
C36 XM13.S Vref 0.89296f
C37 Vref XM14.D 0.40278f
C38 XM2.S Vref 0.00362f
C39 XM1.D VDD 2.4817f
C40 VOUT XM2.S 1.25459f
C41 XM13.S XM1.S 0
C42 XM1.D XM7.S 0.00665f
C43 XR2.R1 XR1.R2 0.00461f
C44 XM2.S XM1.S 0.0471f
C45 XM13.S XM7.G 0.00608f
C46 XM7.G XM14.D 0.19693f
C47 Vref XR2.R1 0.0305f
C48 XM2.S XM7.G 0.03905f
C49 Vref GND 2.06397f
C50 VOUT GND 0.18702p
C51 VDD GND 0.30223p
C52 XR1.R2 GND 8.18597f
C53 XM1.S GND 1.38532f
C54 XR2.R1 GND 1.93382f
C55 XM2.S GND 43.24062f
C56 XM1.D GND 1.02737f
C57 XM7.G GND 5.30437f
C58 XM13.S GND 3.40469f
C59 XM14.D GND 1.5639f
C60 XM7.S GND 21.7871f
C61 XM2.S.t1 GND 0.00883f
C62 XM2.S.t3 GND 39.9637f
C63 XM2.S.n0 GND 0.79201f
C64 XM2.S.t2 GND 0.05135f
C65 XM2.S.n1 GND 0.22857f
C66 XM2.S.t0 GND 0.00601f
C67 VOUT.t0 GND 0.05112f
C68 VOUT.n0 GND 0.92319f
C69 VOUT.t11 GND 0.44345f
C70 VOUT.t24 GND 0.44345f
C71 VOUT.n1 GND 0.88691f
C72 VOUT.t38 GND 0.44345f
C73 VOUT.t45 GND 0.44345f
C74 VOUT.n2 GND 0.88691f
C75 VOUT.t63 GND 0.44345f
C76 VOUT.t47 GND 0.44345f
C77 VOUT.n3 GND 0.88691f
C78 VOUT.t39 GND 0.44345f
C79 VOUT.t58 GND 0.44345f
C80 VOUT.n4 GND 0.88691f
C81 VOUT.t46 GND 0.44345f
C82 VOUT.t64 GND 0.44345f
C83 VOUT.n5 GND 0.88691f
C84 VOUT.t67 GND 0.44345f
C85 VOUT.t9 GND 0.44345f
C86 VOUT.n6 GND 0.88691f
C87 VOUT.t40 GND 0.44345f
C88 VOUT.t26 GND 0.44345f
C89 VOUT.n7 GND 0.88691f
C90 VOUT.t35 GND 0.44345f
C91 VOUT.t50 GND 0.44345f
C92 VOUT.n8 GND 0.88691f
C93 VOUT.t68 GND 0.44345f
C94 VOUT.t1 GND 0.44345f
C95 VOUT.n9 GND 0.88691f
C96 VOUT.t59 GND 0.44345f
C97 VOUT.t5 GND 0.44345f
C98 VOUT.n10 GND 0.88691f
C99 VOUT.t53 GND 0.44345f
C100 VOUT.t70 GND 0.44345f
C101 VOUT.n11 GND 0.88691f
C102 VOUT.t60 GND 0.44345f
C103 VOUT.t3 GND 0.44345f
C104 VOUT.n12 GND 0.88691f
C105 VOUT.t8 GND 0.44345f
C106 VOUT.t48 GND 0.44345f
C107 VOUT.n13 GND 0.88691f
C108 VOUT.t66 GND 0.44345f
C109 VOUT.t42 GND 0.44345f
C110 VOUT.n14 GND 0.88691f
C111 VOUT.t61 GND 0.44345f
C112 VOUT.t4 GND 0.44345f
C113 VOUT.n15 GND 0.88691f
C114 VOUT.t12 GND 0.44345f
C115 VOUT.t19 GND 0.44345f
C116 VOUT.n16 GND 0.88691f
C117 VOUT.t10 GND 0.44345f
C118 VOUT.t54 GND 0.44345f
C119 VOUT.n17 GND 0.88691f
C120 VOUT.t27 GND 0.44345f
C121 VOUT.t20 GND 0.44345f
C122 VOUT.n18 GND 0.88691f
C123 VOUT.t32 GND 0.44345f
C124 VOUT.t37 GND 0.44345f
C125 VOUT.n19 GND 0.88691f
C126 VOUT.t13 GND 0.44345f
C127 VOUT.t25 GND 0.44345f
C128 VOUT.n20 GND 0.88691f
C129 VOUT.t14 GND 0.44345f
C130 VOUT.t21 GND 0.44345f
C131 VOUT.n21 GND 0.88691f
C132 VOUT.t33 GND 0.44345f
C133 VOUT.t49 GND 0.44345f
C134 VOUT.n22 GND 0.88691f
C135 VOUT.t56 GND 0.44345f
C136 VOUT.t43 GND 0.44345f
C137 VOUT.n23 GND 0.88691f
C138 VOUT.t18 GND 0.44345f
C139 VOUT.t28 GND 0.44345f
C140 VOUT.n24 GND 0.88691f
C141 VOUT.n25 GND 6.80785f
C142 VOUT.n26 GND 3.40315f
C143 VOUT.n27 GND 3.40315f
C144 VOUT.n28 GND 3.40315f
C145 VOUT.n29 GND 3.40315f
C146 VOUT.n30 GND 5.22168f
C147 VOUT.n31 GND 5.24336f
C148 VOUT.n32 GND 3.42483f
C149 VOUT.n33 GND 3.42483f
C150 VOUT.n34 GND 3.42483f
C151 VOUT.n35 GND 3.42483f
C152 VOUT.n36 GND 3.42483f
C153 VOUT.n37 GND 5.20989f
C154 VOUT.n38 GND 5.20989f
C155 VOUT.n39 GND 3.42483f
C156 VOUT.n40 GND 3.42483f
C157 VOUT.n41 GND 3.42483f
C158 VOUT.n42 GND 3.42483f
C159 VOUT.n43 GND 3.42483f
C160 VOUT.n44 GND 5.19874f
C161 VOUT.n45 GND 5.20218f
C162 VOUT.n46 GND 3.42827f
C163 VOUT.n47 GND 3.09915f
C164 VOUT.t29 GND 0.44345f
C165 VOUT.t36 GND 0.44345f
C166 VOUT.n48 GND 0.88691f
C167 VOUT.t55 GND 0.44345f
C168 VOUT.t65 GND 0.44345f
C169 VOUT.n49 GND 0.88691f
C170 VOUT.t52 GND 0.44345f
C171 VOUT.t41 GND 0.44345f
C172 VOUT.n50 GND 0.88691f
C173 VOUT.t7 GND 0.44345f
C174 VOUT.t16 GND 0.44345f
C175 VOUT.n51 GND 0.88691f
C176 VOUT.t34 GND 0.44345f
C177 VOUT.t23 GND 0.44345f
C178 VOUT.n52 GND 0.88691f
C179 VOUT.t62 GND 0.44345f
C180 VOUT.t31 GND 0.44345f
C181 VOUT.n53 GND 0.88691f
C182 VOUT.t30 GND 0.44345f
C183 VOUT.t44 GND 0.44345f
C184 VOUT.n54 GND 0.88691f
C185 VOUT.t17 GND 0.44345f
C186 VOUT.t22 GND 0.44345f
C187 VOUT.n55 GND 0.88691f
C188 VOUT.t57 GND 0.44345f
C189 VOUT.t2 GND 0.44345f
C190 VOUT.n56 GND 0.88691f
C191 VOUT.t6 GND 0.44345f
C192 VOUT.t15 GND 0.44345f
C193 VOUT.n57 GND 0.88691f
C194 VOUT.t51 GND 0.44345f
C195 VOUT.t69 GND 0.44345f
C196 VOUT.n58 GND 0.88691f
C197 VOUT.n59 GND 14.799f
C198 VOUT.n60 GND 71.3432f
C199 VOUT.n61 GND 64.3994f
C200 VDD.n0 GND 1.73534f
C201 VDD.n1 GND 2.48017f
C202 VDD.n2 GND 0.30006f
C203 VDD.n3 GND 0.30006f
C204 VDD.t90 GND 1.25594f
C205 VDD.t56 GND 1.25594f
C206 VDD.n4 GND 2.35313f
C207 VDD.n5 GND 0.30131f
C208 VDD.n6 GND 0.30131f
C209 VDD.n7 GND 1.74f
C210 VDD.n8 GND 2.74188f
C211 VDD.n9 GND 0.30006f
C212 VDD.n10 GND 5.84383f
C213 VDD.n11 GND 2.49849f
C214 VDD.t60 GND 2.13652f
C215 VDD.t86 GND 1.67458f
C216 VDD.t104 GND 1.67458f
C217 VDD.t136 GND 1.67458f
C218 VDD.t124 GND 1.67458f
C219 VDD.t132 GND 1.67458f
C220 VDD.t20 GND 1.25594f
C221 VDD.t36 GND 2.00165f
C222 VDD.t22 GND 1.67458f
C223 VDD.t8 GND 1.67458f
C224 VDD.t116 GND 1.67458f
C225 VDD.t92 GND 1.67458f
C226 VDD.t106 GND 1.67458f
C227 VDD.t32 GND 1.25594f
C228 VDD.n12 GND 5.76643f
C229 VDD.n13 GND 0.30131f
C230 VDD.n14 GND 0.83729f
C231 VDD.n15 GND 0.30131f
C232 VDD.n16 GND 1.73267f
C233 VDD.n17 GND 0.7775f
C234 VDD.n18 GND 0.30006f
C235 VDD.n19 GND 1.74f
C236 VDD.t34 GND 2.00165f
C237 VDD.t46 GND 1.67458f
C238 VDD.t70 GND 1.67458f
C239 VDD.t48 GND 1.67458f
C240 VDD.t62 GND 1.67458f
C241 VDD.t74 GND 1.67458f
C242 VDD.t112 GND 1.25594f
C243 VDD.n20 GND 0.83729f
C244 VDD.t64 GND 1.25594f
C245 VDD.t10 GND 1.67458f
C246 VDD.t50 GND 1.67458f
C247 VDD.t80 GND 1.67458f
C248 VDD.t72 GND 1.67458f
C249 VDD.t110 GND 1.67458f
C250 VDD.t96 GND 2.00165f
C251 VDD.t26 GND 1.67458f
C252 VDD.t138 GND 1.67458f
C253 VDD.t108 GND 1.67458f
C254 VDD.t94 GND 1.67458f
C255 VDD.t126 GND 1.67458f
C256 VDD.t88 GND 2.00165f
C257 VDD.n21 GND 1.74004f
C258 VDD.n22 GND 1.74004f
C259 VDD.n23 GND 0.30006f
C260 VDD.n24 GND 0.38875f
C261 VDD.n25 GND 0.38875f
C262 VDD.n26 GND 2.73613f
C263 VDD.n27 GND 1.1739f
C264 VDD.n28 GND 0.44221f
C265 VDD.t27 GND 0.17442f
C266 VDD.t91 GND 0.17442f
C267 VDD.n29 GND 0.34884f
C268 VDD.t109 GND 0.17442f
C269 VDD.t139 GND 0.17442f
C270 VDD.n30 GND 0.34884f
C271 VDD.t127 GND 0.17442f
C272 VDD.t95 GND 0.17442f
C273 VDD.n31 GND 0.34884f
C274 VDD.t89 GND 1.34757f
C275 VDD.t97 GND 0.63238f
C276 VDD.t73 GND 0.17442f
C277 VDD.t111 GND 0.17442f
C278 VDD.n32 GND 0.34884f
C279 VDD.t51 GND 0.17442f
C280 VDD.t81 GND 0.17442f
C281 VDD.n33 GND 0.34884f
C282 VDD.t65 GND 0.17442f
C283 VDD.t11 GND 0.17442f
C284 VDD.n34 GND 0.34884f
C285 VDD.t75 GND 0.17442f
C286 VDD.t113 GND 0.17442f
C287 VDD.n35 GND 0.34884f
C288 VDD.t49 GND 0.17442f
C289 VDD.t63 GND 0.17442f
C290 VDD.n36 GND 0.34884f
C291 VDD.t47 GND 0.17442f
C292 VDD.t71 GND 0.17442f
C293 VDD.n37 GND 0.34884f
C294 VDD.t35 GND 1.33888f
C295 VDD.t37 GND 0.63238f
C296 VDD.t9 GND 0.17442f
C297 VDD.t23 GND 0.17442f
C298 VDD.n38 GND 0.34884f
C299 VDD.t93 GND 0.17442f
C300 VDD.t117 GND 0.17442f
C301 VDD.n39 GND 0.34884f
C302 VDD.t33 GND 0.17442f
C303 VDD.t107 GND 0.17442f
C304 VDD.n40 GND 0.34884f
C305 VDD.t133 GND 0.17442f
C306 VDD.t21 GND 0.17442f
C307 VDD.n41 GND 0.34884f
C308 VDD.t137 GND 0.17442f
C309 VDD.t125 GND 0.17442f
C310 VDD.n42 GND 0.34884f
C311 VDD.t87 GND 0.17442f
C312 VDD.t105 GND 0.17442f
C313 VDD.n43 GND 0.34884f
C314 VDD.t61 GND 1.35283f
C315 VDD.n44 GND 2.47133f
C316 VDD.n45 GND 0.76584f
C317 VDD.n46 GND 0.76584f
C318 VDD.n47 GND 0.76584f
C319 VDD.n48 GND 0.76584f
C320 VDD.n49 GND 0.76584f
C321 VDD.n50 GND 0.8257f
C322 VDD.n51 GND 1.8894f
C323 VDD.n52 GND 0.76595f
C324 VDD.n53 GND 0.76595f
C325 VDD.n54 GND 0.76595f
C326 VDD.n55 GND 0.76595f
C327 VDD.n56 GND 0.76595f
C328 VDD.n57 GND 0.76595f
C329 VDD.n58 GND 0.83201f
C330 VDD.n59 GND 1.89066f
C331 VDD.n60 GND 0.7639f
C332 VDD.n61 GND 0.7639f
C333 VDD.n62 GND 0.64723f
C334 VDD.t57 GND 0.17442f
C335 VDD.t85 GND 0.17442f
C336 VDD.n63 GND 0.34884f
C337 VDD.t99 GND 0.17442f
C338 VDD.t141 GND 0.17442f
C339 VDD.n64 GND 0.34884f
C340 VDD.t5 GND 0.17442f
C341 VDD.t129 GND 0.17442f
C342 VDD.n65 GND 0.34884f
C343 VDD.t17 GND 0.63238f
C344 VDD.t121 GND 1.34757f
C345 VDD.t143 GND 0.17442f
C346 VDD.t131 GND 0.17442f
C347 VDD.n66 GND 0.34884f
C348 VDD.t13 GND 0.17442f
C349 VDD.t25 GND 0.17442f
C350 VDD.n67 GND 0.34884f
C351 VDD.t103 GND 0.17442f
C352 VDD.t135 GND 0.17442f
C353 VDD.n68 GND 0.34884f
C354 VDD.t79 GND 0.17442f
C355 VDD.t115 GND 0.17442f
C356 VDD.n69 GND 0.34884f
C357 VDD.t15 GND 0.17442f
C358 VDD.t29 GND 0.17442f
C359 VDD.n70 GND 0.34884f
C360 VDD.t41 GND 0.17442f
C361 VDD.t19 GND 0.17442f
C362 VDD.n71 GND 0.34884f
C363 VDD.t123 GND 0.63238f
C364 VDD.t53 GND 1.34677f
C365 VDD.t43 GND 0.17442f
C366 VDD.t67 GND 0.17442f
C367 VDD.n72 GND 0.34884f
C368 VDD.t83 GND 0.17442f
C369 VDD.t7 GND 0.17442f
C370 VDD.n73 GND 0.34884f
C371 VDD.t55 GND 0.17442f
C372 VDD.t31 GND 0.17442f
C373 VDD.n74 GND 0.34884f
C374 VDD.t45 GND 0.17442f
C375 VDD.t69 GND 0.17442f
C376 VDD.n75 GND 0.34884f
C377 VDD.t101 GND 0.17442f
C378 VDD.t119 GND 0.17442f
C379 VDD.n76 GND 0.34884f
C380 VDD.t77 GND 0.17442f
C381 VDD.t39 GND 0.17442f
C382 VDD.n77 GND 0.34884f
C383 VDD.t59 GND 0.63238f
C384 VDD.n78 GND 0.38867f
C385 VDD.n79 GND 0.75814f
C386 VDD.n80 GND 0.75814f
C387 VDD.n81 GND 0.75814f
C388 VDD.n82 GND 0.75814f
C389 VDD.n83 GND 0.75814f
C390 VDD.n84 GND 1.90276f
C391 VDD.n85 GND 0.83614f
C392 VDD.n86 GND 0.7639f
C393 VDD.n87 GND 0.7639f
C394 VDD.n88 GND 0.7639f
C395 VDD.n89 GND 0.7639f
C396 VDD.n90 GND 0.7639f
C397 VDD.n91 GND 0.7639f
C398 VDD.n92 GND 1.8886f
C399 VDD.n93 GND 0.82807f
C400 VDD.n94 GND 0.7639f
C401 VDD.n95 GND 0.7639f
C402 VDD.n96 GND 0.63907f
C403 VDD.n97 GND 0.67334f
C404 VDD.n98 GND 10.1797f
C405 VDD.n99 GND 10.1493f
C406 VDD.n100 GND 0.79024f
C407 VDD.n101 GND 2.77981f
C408 VDD.n102 GND 0.30006f
C409 VDD.n103 GND 0.30006f
C410 VDD.t84 GND 1.67458f
C411 VDD.t98 GND 1.67458f
C412 VDD.t140 GND 1.67458f
C413 VDD.t4 GND 1.67458f
C414 VDD.t128 GND 1.67458f
C415 VDD.t16 GND 2.00165f
C416 VDD.n104 GND 1.75308f
C417 VDD.n105 GND 1.75308f
C418 VDD.t120 GND 2.00165f
C419 VDD.t142 GND 1.67458f
C420 VDD.t130 GND 1.67458f
C421 VDD.t12 GND 1.67458f
C422 VDD.t24 GND 1.67458f
C423 VDD.t102 GND 1.67458f
C424 VDD.t134 GND 1.25594f
C425 VDD.n106 GND 0.30131f
C426 VDD.t52 GND 2.00165f
C427 VDD.n107 GND 0.30131f
C428 VDD.n108 GND 0.30131f
C429 VDD.n109 GND 1.58854f
C430 VDD.n110 GND 1.35272f
C431 VDD.n111 GND 0.04162f
C432 VDD.n112 GND 0.04162f
C433 VDD.n113 GND 0.33153f
C434 VDD.n114 GND 0.25556f
C435 VDD.n115 GND 0.25884f
C436 VDD.n116 GND 0.04165f
C437 VDD.n117 GND 0.04165f
C438 VDD.n118 GND 0.26784f
C439 VDD.n119 GND 1.37094f
C440 VDD.n120 GND 0.21569f
C441 VDD.n121 GND 0.04165f
C442 VDD.t146 GND 0.39401f
C443 VDD.n123 GND 0.28844f
C444 VDD.n124 GND 4.12574f
C445 VDD.n125 GND 3.57326f
C446 VDD.n126 GND 6.38223f
C447 VDD.t42 GND 1.67458f
C448 VDD.t66 GND 1.67458f
C449 VDD.t82 GND 1.67458f
C450 VDD.t6 GND 1.67458f
C451 VDD.t54 GND 1.67458f
C452 VDD.t30 GND 1.25594f
C453 VDD.n127 GND 0.83729f
C454 VDD.t44 GND 1.25594f
C455 VDD.t68 GND 1.67458f
C456 VDD.t100 GND 1.67458f
C457 VDD.t118 GND 1.67458f
C458 VDD.t76 GND 1.67458f
C459 VDD.t38 GND 1.67458f
C460 VDD.t58 GND 2.13652f
C461 VDD.n128 GND 2.02294f
C462 VDD.t147 GND 0.02523f
C463 VDD.t149 GND 0.02523f
C464 VDD.t151 GND 0.02523f
C465 VDD.t3 GND 0.01302f
C466 VDD.t1 GND 0.01302f
C467 VDD.n129 GND 0.20284f
C468 VDD.t145 GND 0.10645f
C469 VDD.n130 GND 0.09516f
C470 VDD.n131 GND 0.06703f
C471 VDD.n132 GND 0.14933f
C472 VDD.n133 GND 0.03768f
C473 VDD.n134 GND 0.06952f
C474 VDD.n135 GND 0.03768f
C475 VDD.n136 GND 0.22586f
C476 VDD.n137 GND 0.28442f
C477 VDD.n138 GND 0.54635f
C478 VDD.n139 GND 0.46113f
C479 VDD.n140 GND 0.46113f
C480 VDD.n141 GND 0.60409f
C481 VDD.n142 GND 2.51806f
C482 VDD.n143 GND 1.37827f
C483 VDD.n144 GND 0.06322f
C484 VDD.t144 GND 0.62173f
C485 VDD.n147 GND 0.06322f
C486 VDD.n148 GND 0.37945f
C487 VDD.n149 GND 0.42397f
C488 VDD.n150 GND 0.24157f
C489 VDD.n151 GND 0.03768f
C490 VDD.n152 GND 0.22586f
C491 VDD.n153 GND 0.03741f
C492 VDD.t0 GND 0.33649f
C493 VDD.n155 GND 0.03741f
C494 VDD.n156 GND 0.20869f
C495 VDD.n157 GND 0.03741f
C496 VDD.t2 GND 0.31452f
C497 VDD.n158 GND 0.03741f
C498 VDD.n159 GND 0.09253f
C499 VDD.n160 GND 0.07819f
C500 VDD.n161 GND 3.51179f
C501 VDD.n162 GND 3.15318f
C502 VDD.n163 GND 0.93127f
C503 VDD.n164 GND 0.62204f
C504 VDD.n165 GND 0.59791f
C505 VDD.n166 GND 0.90611f
C506 VDD.n167 GND 0.27585f
C507 VDD.n168 GND 0.27296f
C508 VDD.n169 GND 2.33583f
C509 VDD.n170 GND 1.32453f
C510 VDD.n171 GND 0.31781f
C511 VDD.n172 GND 0.42665f
C512 VDD.n173 GND 0.84047f
C513 VDD.n174 GND 4.6467f
C514 VDD.n175 GND 4.10325f
C515 VDD.n176 GND 2.88057f
C516 VDD.n177 GND 7.06285f
C517 VDD.n178 GND 5.10175f
C518 VDD.n179 GND 0.49019f
C519 VDD.n180 GND 0.04165f
C520 VDD.n181 GND 0.04162f
C521 VDD.n182 GND 0.08387f
C522 VDD.n183 GND 0.04162f
C523 VDD.n184 GND 0.26784f
C524 VDD.t150 GND 0.37298f
C525 VDD.n185 GND 0.25556f
C526 VDD.n186 GND 0.04162f
C527 VDD.n187 GND 0.07428f
C528 VDD.n188 GND 0.2062f
C529 VDD.n189 GND 0.04165f
C530 VDD.t148 GND 0.37298f
C531 VDD.n190 GND 0.04165f
C532 VDD.n191 GND 4.46582f
C533 VDD.n192 GND 4.77904f
C534 VDD.n193 GND 0.84123f
C535 VDD.n194 GND 0.30006f
C536 VDD.n195 GND 1.80541f
C537 VDD.n196 GND 1.80541f
C538 VDD.t122 GND 2.00165f
C539 VDD.t18 GND 1.67458f
C540 VDD.t40 GND 1.67458f
C541 VDD.t28 GND 1.67458f
C542 VDD.t14 GND 1.67458f
C543 VDD.t114 GND 1.67458f
C544 VDD.t78 GND 1.25594f
C545 VDD.n197 GND 0.83729f
C546 VDD.n198 GND 0.30131f
C547 VDD.n199 GND 2.35474f
C548 VDD.n200 GND 2.30097f
C549 VDD.n201 GND 0.76412f
C550 VDD.n202 GND 10.4859f
C551 VDD.n203 GND 0.40496f
C552 VDD.n204 GND 0.37946f
C553 VDD.n205 GND 0.41102f
C554 VDD.n206 GND 0.00557f
C555 VDD.n207 GND 0.30131f
C556 VDD.n208 GND 0.83729f
C557 VDD.n209 GND 0.30131f
.ends
