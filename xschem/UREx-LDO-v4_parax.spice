* NGSPICE file created from UREx-LDO-v4_parax.ext - technology: sky130A

.subckt UREx-LDO-v4_parax VDD VOUT GND Vref
X0 VDD.t54 XM7.D VOUT.t13 XM12.B sky130_fd_pr__pfet_01v8_lvt ad=5.075 pd=35.29 as=5.075 ps=35.29 w=35 l=0.35
X1 VOUT.t5 XM7.D VDD.t53 XM12.B sky130_fd_pr__pfet_01v8_lvt ad=5.075 pd=35.29 as=5.075 ps=35.29 w=35 l=0.35
X2 VDD.t2 XM4.G XM4.G XM12.B sky130_fd_pr__pfet_01v8_lvt ad=0.145 pd=1.58 as=0.145 ps=1.58 w=0.5 l=1
X3 VDD.t52 XM7.D VOUT.t19 XM12.B sky130_fd_pr__pfet_01v8_lvt ad=5.075 pd=35.29 as=5.075 ps=35.29 w=35 l=0.35
X4 VOUT.t38 XM7.D VDD.t51 XM12.B sky130_fd_pr__pfet_01v8_lvt ad=5.075 pd=35.29 as=5.075 ps=35.29 w=35 l=0.35
X5 VDD.t50 XM7.D VOUT.t30 XM12.B sky130_fd_pr__pfet_01v8_lvt ad=5.075 pd=35.29 as=5.075 ps=35.29 w=35 l=0.35
X6 XR2.R1 XM14.G XM14.D.t0 XR3.B sky130_fd_pr__nfet_01v8_lvt ad=0.638 pd=4.98 as=0.638 ps=4.98 w=2.2 l=1
X7 VDD.t49 XM7.D VOUT.t40 XM12.B sky130_fd_pr__pfet_01v8_lvt ad=5.075 pd=35.29 as=5.075 ps=35.29 w=35 l=0.35
X8 VDD.t48 XM7.D VOUT.t39 XM12.B sky130_fd_pr__pfet_01v8_lvt ad=5.075 pd=35.29 as=5.075 ps=35.29 w=35 l=0.35
X9 XM7.D XM8.S GND.t1 XR3.B sky130_fd_pr__nfet_01v8_lvt ad=1.508 pd=10.98 as=1.508 ps=10.98 w=5.2 l=0.25
X10 VOUT.t28 XM7.D VDD.t47 XM12.B sky130_fd_pr__pfet_01v8_lvt ad=5.075 pd=35.29 as=5.075 ps=35.29 w=35 l=0.35
X11 VOUT.t0 XR3.R1.t0 XR3.B sky130_fd_pr__res_high_po_0p35 l=35.7
X12 VOUT.t29 XM7.D VDD.t46 XM12.B sky130_fd_pr__pfet_01v8_lvt ad=5.075 pd=35.29 as=5.075 ps=35.29 w=35 l=0.35
X13 XM6.G.t0 XM4.G VDD.t3 XM12.B sky130_fd_pr__pfet_01v8_lvt ad=0.145 pd=1.58 as=0.145 ps=1.58 w=0.5 l=1
X14 XM5.D Vref.t0 XM4.G XR3.B sky130_fd_pr__nfet_01v8_lvt ad=0.232 pd=2.18 as=0.232 ps=2.18 w=0.8 l=1
X15 VOUT.t14 XM7.D VDD.t45 XM12.B sky130_fd_pr__pfet_01v8_lvt ad=5.075 pd=35.29 as=5.075 ps=35.29 w=35 l=0.35
X16 VDD.t44 XM7.D VOUT.t6 XM12.B sky130_fd_pr__pfet_01v8_lvt ad=5.075 pd=35.29 as=5.075 ps=35.29 w=35 l=0.35
X17 VOUT.t3 XM7.D VDD.t43 XM12.B sky130_fd_pr__pfet_01v8_lvt ad=5.075 pd=35.29 as=5.075 ps=35.29 w=35 l=0.35
X18 VDD.t42 XM7.D VOUT.t10 XM12.B sky130_fd_pr__pfet_01v8_lvt ad=5.075 pd=35.29 as=5.075 ps=35.29 w=35 l=0.35
X19 VDD.t41 XM7.D VOUT.t45 XM12.B sky130_fd_pr__pfet_01v8_lvt ad=5.075 pd=35.29 as=5.075 ps=35.29 w=35 l=0.35
X20 VOUT.t25 XM7.D VDD.t40 XM12.B sky130_fd_pr__pfet_01v8_lvt ad=5.075 pd=35.29 as=5.075 ps=35.29 w=35 l=0.35
X21 VDD.t39 XM7.D VOUT.t23 XM12.B sky130_fd_pr__pfet_01v8_lvt ad=5.075 pd=35.29 as=5.075 ps=35.29 w=35 l=0.35
X22 VOUT.t48 XM7.D VDD.t38 XM12.B sky130_fd_pr__pfet_01v8_lvt ad=5.075 pd=35.29 as=5.075 ps=35.29 w=35 l=0.35
X23 VDD.t55 XM6.G.t2 XM7.D XM12.B sky130_fd_pr__pfet_01v8_lvt ad=1.218 pd=8.98 as=1.218 ps=8.98 w=4.2 l=0.35
X24 VOUT.t47 XM7.D VDD.t37 XM12.B sky130_fd_pr__pfet_01v8_lvt ad=5.075 pd=35.29 as=5.075 ps=35.29 w=35 l=0.35
X25 VOUT.t46 XM7.D VDD.t36 XM12.B sky130_fd_pr__pfet_01v8_lvt ad=5.075 pd=35.29 as=5.075 ps=35.29 w=35 l=0.35
X26 VDD.t35 XM7.D VOUT.t12 XM12.B sky130_fd_pr__pfet_01v8_lvt ad=10.15 pd=70.58 as=5.075 ps=35.29 w=35 l=0.35
X27 VDD.t34 XM7.D VOUT.t49 XM12.B sky130_fd_pr__pfet_01v8_lvt ad=5.075 pd=35.29 as=5.075 ps=35.29 w=35 l=0.35
X28 VOUT.t17 XM7.D VDD.t33 XM12.B sky130_fd_pr__pfet_01v8_lvt ad=5.075 pd=35.29 as=5.075 ps=35.29 w=35 l=0.35
X29 XM8.S XM8.S GND.t0 XR3.B sky130_fd_pr__nfet_01v8_lvt ad=0.348 pd=2.98 as=0.348 ps=2.98 w=1.2 l=1
X30 VDD.t32 XM7.D VOUT.t18 XM12.B sky130_fd_pr__pfet_01v8_lvt ad=5.075 pd=35.29 as=5.075 ps=35.29 w=35 l=0.35
X31 GND.t2 XM8.S XM5.D XR3.B sky130_fd_pr__nfet_01v8_lvt ad=0.348 pd=2.98 as=0.348 ps=2.98 w=1.2 l=1
X32 VDD.t31 XM7.D VOUT.t21 XM12.B sky130_fd_pr__pfet_01v8_lvt ad=5.075 pd=35.29 as=5.075 ps=35.29 w=35 l=0.35
X33 VDD.t30 XM7.D VOUT.t15 XM12.B sky130_fd_pr__pfet_01v8_lvt ad=5.075 pd=35.29 as=5.075 ps=35.29 w=35 l=0.35
X34 VOUT.t26 XM7.D VDD.t29 XM12.B sky130_fd_pr__pfet_01v8_lvt ad=5.075 pd=35.29 as=5.075 ps=35.29 w=35 l=0.35
X35 VOUT.t43 XM7.D VDD.t28 XM12.B sky130_fd_pr__pfet_01v8_lvt ad=5.075 pd=35.29 as=5.075 ps=35.29 w=35 l=0.35
X36 VOUT.t22 XM7.D VDD.t27 XM12.B sky130_fd_pr__pfet_01v8_lvt ad=5.075 pd=35.29 as=5.075 ps=35.29 w=35 l=0.35
X37 VOUT.t31 XM7.D VDD.t26 XM12.B sky130_fd_pr__pfet_01v8_lvt ad=5.075 pd=35.29 as=5.075 ps=35.29 w=35 l=0.35
X38 GND.t5 XR2.R1 XR3.B sky130_fd_pr__res_high_po_0p35 l=3.1
X39 VDD.t25 XM7.D VOUT.t41 XM12.B sky130_fd_pr__pfet_01v8_lvt ad=5.075 pd=35.29 as=5.075 ps=35.29 w=35 l=0.35
X40 XM14.D.t2 XM14.D.t1 VDD.t4 XM12.B sky130_fd_pr__pfet_01v8_lvt ad=0.29 pd=2.58 as=0.29 ps=2.58 w=1 l=1
X41 VDD.t24 XM7.D VOUT.t11 XM12.B sky130_fd_pr__pfet_01v8_lvt ad=5.075 pd=35.29 as=5.075 ps=35.29 w=35 l=0.35
X42 XM14.G XM14.G GND.t3 XR3.B sky130_fd_pr__nfet_01v8_lvt ad=0.58 pd=4.58 as=0.58 ps=4.58 w=2 l=1
X43 VDD.t23 XM7.D VOUT.t20 XM12.B sky130_fd_pr__pfet_01v8_lvt ad=5.075 pd=35.29 as=5.075 ps=35.29 w=35 l=0.35
X44 VDD.t22 XM7.D VOUT.t42 XM12.B sky130_fd_pr__pfet_01v8_lvt ad=5.075 pd=35.29 as=5.075 ps=35.29 w=35 l=0.35
X45 VDD.t21 XM7.D VOUT.t35 XM12.B sky130_fd_pr__pfet_01v8_lvt ad=5.075 pd=35.29 as=5.075 ps=35.29 w=35 l=0.35
X46 VDD.t20 XM7.D VOUT.t36 XM12.B sky130_fd_pr__pfet_01v8_lvt ad=5.075 pd=35.29 as=5.075 ps=35.29 w=35 l=0.35
X47 VOUT.t33 XM7.D VDD.t19 XM12.B sky130_fd_pr__pfet_01v8_lvt ad=5.075 pd=35.29 as=5.075 ps=35.29 w=35 l=0.35
X48 VOUT.t16 XM7.D VDD.t18 XM12.B sky130_fd_pr__pfet_01v8_lvt ad=5.075 pd=35.29 as=5.075 ps=35.29 w=35 l=0.35
X49 VOUT.t34 XM7.D VDD.t17 XM12.B sky130_fd_pr__pfet_01v8_lvt ad=5.075 pd=35.29 as=10.15 ps=70.58 w=35 l=0.35
X50 VDD.t16 XM7.D VOUT.t1 XM12.B sky130_fd_pr__pfet_01v8_lvt ad=5.075 pd=35.29 as=5.075 ps=35.29 w=35 l=0.35
X51 VOUT.t37 XM7.D VDD.t15 XM12.B sky130_fd_pr__pfet_01v8_lvt ad=5.075 pd=35.29 as=5.075 ps=35.29 w=35 l=0.35
X52 VDD.t14 XM7.D VOUT.t7 XM12.B sky130_fd_pr__pfet_01v8_lvt ad=5.075 pd=35.29 as=5.075 ps=35.29 w=35 l=0.35
X53 VDD.t13 XM7.D VOUT.t2 XM12.B sky130_fd_pr__pfet_01v8_lvt ad=5.075 pd=35.29 as=5.075 ps=35.29 w=35 l=0.35
X54 VDD.t12 XM7.D VOUT.t8 XM12.B sky130_fd_pr__pfet_01v8_lvt ad=5.075 pd=35.29 as=5.075 ps=35.29 w=35 l=0.35
X55 VOUT.t50 XM7.D VDD.t11 XM12.B sky130_fd_pr__pfet_01v8_lvt ad=5.075 pd=35.29 as=5.075 ps=35.29 w=35 l=0.35
X56 GND.t4 XR3.R1.t1 XR3.B sky130_fd_pr__res_high_po_0p35 l=53.9
X57 VOUT.t32 XM7.D VDD.t10 XM12.B sky130_fd_pr__pfet_01v8_lvt ad=5.075 pd=35.29 as=5.075 ps=35.29 w=35 l=0.35
X58 VDD.t1 XM14.D.t3 XM14.G XM12.B sky130_fd_pr__pfet_01v8_lvt ad=0.29 pd=2.58 as=0.29 ps=2.58 w=1 l=1
X59 VOUT.t9 XM7.D VDD.t9 XM12.B sky130_fd_pr__pfet_01v8_lvt ad=5.075 pd=35.29 as=5.075 ps=35.29 w=35 l=0.35
X60 VOUT.t4 XM7.D VDD.t8 XM12.B sky130_fd_pr__pfet_01v8_lvt ad=5.075 pd=35.29 as=5.075 ps=35.29 w=35 l=0.35
X61 XM8.S XM14.D.t4 VDD.t0 XM12.B sky130_fd_pr__pfet_01v8_lvt ad=0.29 pd=2.58 as=0.29 ps=2.58 w=1 l=1
X62 VOUT.t44 XM7.D VDD.t7 XM12.B sky130_fd_pr__pfet_01v8_lvt ad=5.075 pd=35.29 as=5.075 ps=35.29 w=35 l=0.35
X63 XM6.G.t3 XM7.D sky130_fd_pr__cap_mim_m3_1 l=30 w=30
X64 XM6.G.t1 XR3.R1.t2 XM5.D XR3.B sky130_fd_pr__nfet_01v8_lvt ad=0.232 pd=2.18 as=0.232 ps=2.18 w=0.8 l=1
X65 VDD.t6 XM7.D VOUT.t27 XM12.B sky130_fd_pr__pfet_01v8_lvt ad=5.075 pd=35.29 as=5.075 ps=35.29 w=35 l=0.35
X66 VOUT.t24 XM7.D VDD.t5 XM12.B sky130_fd_pr__pfet_01v8_lvt ad=5.075 pd=35.29 as=5.075 ps=35.29 w=35 l=0.35
R0 VOUT.n59 VOUT.t0 41.0016
R1 VOUT.n59 VOUT 33.0976
R2 VOUT.n60 VOUT.n59 15.3512
R3 VOUT.n19 VOUT 8.77548
R4 VOUT.n19 VOUT 8.71199
R5 VOUT.n20 VOUT 8.71199
R6 VOUT.n21 VOUT 8.71199
R7 VOUT.n27 VOUT 8.71199
R8 VOUT.n28 VOUT 8.71199
R9 VOUT.n29 VOUT 8.71199
R10 VOUT.n30 VOUT 8.71199
R11 VOUT.n34 VOUT 8.71199
R12 VOUT.n33 VOUT 8.71199
R13 VOUT.n14 VOUT 8.71199
R14 VOUT.n39 VOUT 8.71199
R15 VOUT.n40 VOUT 8.71199
R16 VOUT.n41 VOUT 8.71199
R17 VOUT.n42 VOUT 8.71199
R18 VOUT.n44 VOUT 8.71199
R19 VOUT.n45 VOUT 8.71199
R20 VOUT.n46 VOUT 8.71199
R21 VOUT.n47 VOUT 8.71199
R22 VOUT.n53 VOUT 8.71199
R23 VOUT.n52 VOUT 8.71199
R24 VOUT.n51 VOUT 8.71199
R25 VOUT.n3 VOUT 8.71199
R26 VOUT.n58 VOUT 8.71199
R27 VOUT VOUT.n60 8.71199
R28 VOUT VOUT.n18 5.68011
R29 VOUT VOUT.n17 5.68011
R30 VOUT VOUT.n16 5.68011
R31 VOUT VOUT.n15 5.68011
R32 VOUT VOUT.n26 5.68011
R33 VOUT VOUT.n25 5.68011
R34 VOUT VOUT.n24 5.68011
R35 VOUT VOUT.n23 5.68011
R36 VOUT VOUT.n31 5.68011
R37 VOUT VOUT.n32 5.68011
R38 VOUT VOUT.n13 5.68011
R39 VOUT VOUT.n12 5.68011
R40 VOUT VOUT.n11 5.68011
R41 VOUT VOUT.n10 5.68011
R42 VOUT VOUT.n9 5.68011
R43 VOUT VOUT.n8 5.68011
R44 VOUT VOUT.n7 5.68011
R45 VOUT VOUT.n6 5.68011
R46 VOUT VOUT.n5 5.68011
R47 VOUT VOUT.n48 5.68011
R48 VOUT VOUT.n49 5.68011
R49 VOUT VOUT.n50 5.68011
R50 VOUT VOUT.n2 5.68011
R51 VOUT VOUT.n1 5.68011
R52 VOUT VOUT.n0 5.68011
R53 VOUT.n18 VOUT.t12 0.816643
R54 VOUT.n18 VOUT.t48 0.816643
R55 VOUT.n17 VOUT.t35 0.816643
R56 VOUT.n17 VOUT.t31 0.816643
R57 VOUT.n16 VOUT.t2 0.816643
R58 VOUT.n16 VOUT.t24 0.816643
R59 VOUT.n15 VOUT.t42 0.816643
R60 VOUT.n15 VOUT.t4 0.816643
R61 VOUT.n26 VOUT.t30 0.816643
R62 VOUT.n26 VOUT.t25 0.816643
R63 VOUT.n25 VOUT.t45 0.816643
R64 VOUT.n25 VOUT.t3 0.816643
R65 VOUT.n24 VOUT.t21 0.816643
R66 VOUT.n24 VOUT.t46 0.816643
R67 VOUT.n23 VOUT.t41 0.816643
R68 VOUT.n23 VOUT.t50 0.816643
R69 VOUT.n31 VOUT.t7 0.816643
R70 VOUT.n31 VOUT.t37 0.816643
R71 VOUT.n32 VOUT.t27 0.816643
R72 VOUT.n32 VOUT.t29 0.816643
R73 VOUT.n13 VOUT.t39 0.816643
R74 VOUT.n13 VOUT.t38 0.816643
R75 VOUT.n12 VOUT.t10 0.816643
R76 VOUT.n12 VOUT.t26 0.816643
R77 VOUT.n11 VOUT.t49 0.816643
R78 VOUT.n11 VOUT.t16 0.816643
R79 VOUT.n10 VOUT.t36 0.816643
R80 VOUT.n10 VOUT.t44 0.816643
R81 VOUT.n9 VOUT.t8 0.816643
R82 VOUT.n9 VOUT.t5 0.816643
R83 VOUT.n8 VOUT.t6 0.816643
R84 VOUT.n8 VOUT.t9 0.816643
R85 VOUT.n7 VOUT.t40 0.816643
R86 VOUT.n7 VOUT.t17 0.816643
R87 VOUT.n6 VOUT.t20 0.816643
R88 VOUT.n6 VOUT.t22 0.816643
R89 VOUT.n5 VOUT.t15 0.816643
R90 VOUT.n5 VOUT.t33 0.816643
R91 VOUT.n48 VOUT.t11 0.816643
R92 VOUT.n48 VOUT.t32 0.816643
R93 VOUT.n49 VOUT.t19 0.816643
R94 VOUT.n49 VOUT.t28 0.816643
R95 VOUT.n50 VOUT.t13 0.816643
R96 VOUT.n50 VOUT.t14 0.816643
R97 VOUT.n2 VOUT.t18 0.816643
R98 VOUT.n2 VOUT.t47 0.816643
R99 VOUT.n1 VOUT.t23 0.816643
R100 VOUT.n1 VOUT.t43 0.816643
R101 VOUT.n0 VOUT.t1 0.816643
R102 VOUT.n0 VOUT.t34 0.816643
R103 VOUT.n36 VOUT.n22 0.357554
R104 VOUT.n55 VOUT.n54 0.1805
R105 VOUT.n43 VOUT.n4 0.1805
R106 VOUT.n38 VOUT.n37 0.1805
R107 VOUT.n36 VOUT.n35 0.1805
R108 VOUT.n57 VOUT.n56 0.1805
R109 VOUT.n37 VOUT.n36 0.177554
R110 VOUT.n37 VOUT.n4 0.177554
R111 VOUT.n55 VOUT.n4 0.177554
R112 VOUT.n56 VOUT.n55 0.177275
R113 VOUT.n56 VOUT 0.155184
R114 VOUT.n20 VOUT.n19 0.0447732
R115 VOUT.n21 VOUT.n20 0.0127418
R116 VOUT.n28 VOUT.n27 0.0127418
R117 VOUT.n29 VOUT.n28 0.0127418
R118 VOUT.n30 VOUT.n29 0.0127418
R119 VOUT.n34 VOUT.n33 0.0127418
R120 VOUT.n33 VOUT.n14 0.0127418
R121 VOUT.n40 VOUT.n39 0.0127418
R122 VOUT.n41 VOUT.n40 0.0127418
R123 VOUT.n42 VOUT.n41 0.0127418
R124 VOUT.n45 VOUT.n44 0.0127418
R125 VOUT.n46 VOUT.n45 0.0127418
R126 VOUT.n47 VOUT.n46 0.0127418
R127 VOUT.n53 VOUT.n52 0.0127418
R128 VOUT.n52 VOUT.n51 0.0127418
R129 VOUT.n51 VOUT.n3 0.0127418
R130 VOUT.n60 VOUT.n58 0.0127418
R131 VOUT.n38 VOUT.n14 0.0126461
R132 VOUT.n35 VOUT.n34 0.0116897
R133 VOUT.n43 VOUT.n42 0.0114985
R134 VOUT.n27 VOUT.n22 0.0105421
R135 VOUT.n54 VOUT.n47 0.0103508
R136 VOUT.n57 VOUT.n3 0.00920314
R137 VOUT.n58 VOUT.n57 0.00403864
R138 VOUT.n54 VOUT.n53 0.00289097
R139 VOUT.n22 VOUT.n21 0.00269969
R140 VOUT.n44 VOUT.n43 0.00174331
R141 VOUT.n35 VOUT.n30 0.00155203
R142 VOUT.n39 VOUT.n38 0.000595639
R143 VDD VDD.t3 642.13
R144 VDD VDD.t2 642.13
R145 VDD VDD.t1 223.565
R146 VDD VDD.t4 223.565
R147 VDD VDD.t0 223.565
R148 VDD VDD.t55 55.5517
R149 VDD.n28 VDD.t35 15.5644
R150 VDD.n0 VDD 9.38932
R151 VDD.n0 VDD 9.38712
R152 VDD.n60 VDD 9.06867
R153 VDD.n31 VDD 9.03667
R154 VDD.n60 VDD 9.03667
R155 VDD.n58 VDD 9.03667
R156 VDD.n57 VDD 9.03667
R157 VDD.n56 VDD 9.03667
R158 VDD.n55 VDD 9.03667
R159 VDD.n53 VDD 9.03667
R160 VDD.n52 VDD 9.03667
R161 VDD.n51 VDD 9.03667
R162 VDD.n50 VDD 9.03667
R163 VDD.n15 VDD 9.03667
R164 VDD.n43 VDD 9.03667
R165 VDD.n44 VDD 9.03667
R166 VDD.n45 VDD 9.03667
R167 VDD.n39 VDD 9.03667
R168 VDD.n38 VDD 9.03667
R169 VDD.n37 VDD 9.03667
R170 VDD.n36 VDD 9.03667
R171 VDD.n34 VDD 9.03667
R172 VDD.n33 VDD 9.03667
R173 VDD.n32 VDD 9.03667
R174 VDD.n30 VDD 9.03667
R175 VDD.n29 VDD 9.03667
R176 VDD.n28 VDD 9.03667
R177 VDD VDD.t17 6.49625
R178 VDD VDD.n24 5.68011
R179 VDD VDD.n59 5.68011
R180 VDD VDD.n6 5.68011
R181 VDD VDD.n7 5.68011
R182 VDD VDD.n8 5.68011
R183 VDD VDD.n9 5.68011
R184 VDD VDD.n10 5.68011
R185 VDD VDD.n11 5.68011
R186 VDD VDD.n12 5.68011
R187 VDD VDD.n13 5.68011
R188 VDD VDD.n14 5.68011
R189 VDD VDD.n42 5.68011
R190 VDD VDD.n41 5.68011
R191 VDD VDD.n40 5.68011
R192 VDD VDD.n17 5.68011
R193 VDD VDD.n18 5.68011
R194 VDD VDD.n19 5.68011
R195 VDD VDD.n20 5.68011
R196 VDD VDD.n21 5.68011
R197 VDD VDD.n22 5.68011
R198 VDD VDD.n23 5.68011
R199 VDD VDD.n25 5.68011
R200 VDD VDD.n26 5.68011
R201 VDD VDD.n27 5.68011
R202 VDD.n2 VDD 4.86671
R203 VDD.n3 VDD 4.65123
R204 VDD.n3 VDD 4.6505
R205 VDD VDD.n65 2.08383
R206 VDD.n1 VDD 1.54458
R207 VDD.n63 VDD.n62 1.378
R208 VDD.n24 VDD.t8 0.816643
R209 VDD.n24 VDD.t50 0.816643
R210 VDD.n59 VDD.t28 0.816643
R211 VDD.n59 VDD.t16 0.816643
R212 VDD.n6 VDD.t37 0.816643
R213 VDD.n6 VDD.t39 0.816643
R214 VDD.n7 VDD.t45 0.816643
R215 VDD.n7 VDD.t32 0.816643
R216 VDD.n8 VDD.t47 0.816643
R217 VDD.n8 VDD.t54 0.816643
R218 VDD.n9 VDD.t10 0.816643
R219 VDD.n9 VDD.t52 0.816643
R220 VDD.n10 VDD.t19 0.816643
R221 VDD.n10 VDD.t24 0.816643
R222 VDD.n11 VDD.t27 0.816643
R223 VDD.n11 VDD.t30 0.816643
R224 VDD.n12 VDD.t33 0.816643
R225 VDD.n12 VDD.t23 0.816643
R226 VDD.n13 VDD.t9 0.816643
R227 VDD.n13 VDD.t49 0.816643
R228 VDD.n14 VDD.t53 0.816643
R229 VDD.n14 VDD.t44 0.816643
R230 VDD.n42 VDD.t7 0.816643
R231 VDD.n42 VDD.t12 0.816643
R232 VDD.n41 VDD.t18 0.816643
R233 VDD.n41 VDD.t20 0.816643
R234 VDD.n40 VDD.t29 0.816643
R235 VDD.n40 VDD.t34 0.816643
R236 VDD.n17 VDD.t51 0.816643
R237 VDD.n17 VDD.t42 0.816643
R238 VDD.n18 VDD.t46 0.816643
R239 VDD.n18 VDD.t48 0.816643
R240 VDD.n19 VDD.t15 0.816643
R241 VDD.n19 VDD.t6 0.816643
R242 VDD.n20 VDD.t11 0.816643
R243 VDD.n20 VDD.t14 0.816643
R244 VDD.n21 VDD.t36 0.816643
R245 VDD.n21 VDD.t25 0.816643
R246 VDD.n22 VDD.t43 0.816643
R247 VDD.n22 VDD.t31 0.816643
R248 VDD.n23 VDD.t40 0.816643
R249 VDD.n23 VDD.t41 0.816643
R250 VDD.n25 VDD.t5 0.816643
R251 VDD.n25 VDD.t22 0.816643
R252 VDD.n26 VDD.t26 0.816643
R253 VDD.n26 VDD.t13 0.816643
R254 VDD.n27 VDD.t38 0.816643
R255 VDD.n27 VDD.t21 0.816643
R256 VDD.n2 VDD.n1 0.749976
R257 VDD.n65 VDD 0.6255
R258 VDD.n4 VDD.n2 0.429883
R259 VDD.n63 VDD.n4 0.382057
R260 VDD.n31 VDD.n16 0.310708
R261 VDD.n65 VDD.n64 0.292167
R262 VDD.n62 VDD.n61 0.1805
R263 VDD.n54 VDD.n5 0.1805
R264 VDD.n49 VDD.n48 0.1805
R265 VDD.n47 VDD.n46 0.1805
R266 VDD.n35 VDD.n16 0.1805
R267 VDD.n1 VDD.n0 0.149483
R268 VDD.n47 VDD.n16 0.130708
R269 VDD.n48 VDD.n47 0.130708
R270 VDD.n48 VDD.n5 0.130708
R271 VDD.n62 VDD.n5 0.130708
R272 VDD.n4 VDD.n3 0.110149
R273 VDD.n29 VDD.n28 0.0325
R274 VDD.n30 VDD.n29 0.0325
R275 VDD.n31 VDD.n30 0.0325
R276 VDD.n32 VDD.n31 0.0325
R277 VDD.n33 VDD.n32 0.0325
R278 VDD.n34 VDD.n33 0.0325
R279 VDD.n37 VDD.n36 0.0325
R280 VDD.n38 VDD.n37 0.0325
R281 VDD.n39 VDD.n38 0.0325
R282 VDD.n45 VDD.n44 0.0325
R283 VDD.n44 VDD.n43 0.0325
R284 VDD.n43 VDD.n15 0.0325
R285 VDD.n51 VDD.n50 0.0325
R286 VDD.n52 VDD.n51 0.0325
R287 VDD.n53 VDD.n52 0.0325
R288 VDD.n56 VDD.n55 0.0325
R289 VDD.n57 VDD.n56 0.0325
R290 VDD.n58 VDD.n57 0.0325
R291 VDD.n35 VDD.n34 0.0295
R292 VDD.n46 VDD.n39 0.0265
R293 VDD.n49 VDD.n15 0.0235
R294 VDD.n54 VDD.n53 0.0205
R295 VDD.n61 VDD.n58 0.0175
R296 VDD.n61 VDD.n60 0.0155
R297 VDD.n55 VDD.n54 0.0125
R298 VDD.n64 VDD.n63 0.00962287
R299 VDD.n50 VDD.n49 0.0095
R300 VDD.n46 VDD.n45 0.0065
R301 VDD.n36 VDD.n35 0.0035
R302 VDD.n64 VDD 0.00285507
R303 XM14.D XM14.D.t2 223.565
R304 XM14.D.n0 XM14.D.t3 120.409
R305 XM14.D.n2 XM14.D.t4 120.346
R306 XM14.D.n1 XM14.D.t1 120.174
R307 XM14.D.t3 XM14.D 115.525
R308 XM14.D.t1 XM14.D 115.525
R309 XM14.D.t4 XM14.D 115.525
R310 XM14.D XM14.D.t0 38.7429
R311 XM14.D.n0 XM14.D 30.5163
R312 XM14.D XM14.D.n2 1.99945
R313 XM14.D.n2 XM14.D.n1 0.195426
R314 XM14.D.n1 XM14.D.n0 0.132926
R315 GND GND.t2 76.1672
R316 GND GND.t0 76.1672
R317 GND.n0 GND.t5 41.0016
R318 GND.n6 GND.t4 41.0016
R319 GND GND.t3 39.5338
R320 GND.n0 GND 33.0976
R321 GND GND.n6 33.0976
R322 GND GND.t1 15.68
R323 GND.n3 GND 3.39469
R324 GND.n2 GND 3.19695
R325 GND.n1 GND 2.04728
R326 GND.n6 GND.n5 1.613
R327 GND.n1 GND.n0 1.5505
R328 GND.n2 GND 1.36465
R329 GND.n4 GND.n3 0.372109
R330 GND.n3 GND.n2 0.334964
R331 GND.n5 GND 0.237314
R332 GND.n4 GND.n1 0.0394574
R333 GND.n5 GND.n4 0.000984496
R334 XR3.R1 XR3.R1.t2 108.535
R335 XR3.R1.n0 XR3.R1.t1 40.8142
R336 XR3.R1.n1 XR3.R1.t0 40.8142
R337 XR3.R1.n1 XR3.R1 33.275
R338 XR3.R1.n0 XR3.R1 33.275
R339 XR3.R1 XR3.R1.n2 13.0292
R340 XR3.R1.n2 XR3.R1.n0 1.68495
R341 XR3.R1.n2 XR3.R1.n1 1.55639
R342 XM6.G XM6.G.t0 642.13
R343 XM6.G.n0 XM6.G.t2 494.767
R344 XM6.G.t2 XM6.G 485.269
R345 XM6.G XM6.G.t1 114.251
R346 XM6.G XM6.G.n0 9.3469
R347 XM6.G.n0 XM6.G 5.27471
R348 XM6.G XM6.G.t3 0.00132177
R349 Vref Vref.t0 108.535
C0 Vref XM12.B 0.07418f
C1 XM14.D XM8.S 0.15105f
C2 XM14.G XM8.S 0.01188f
C3 XM14.D XM7.D 0.11075f
C4 XM14.G XM7.D 0.0316f
C5 XM14.D VDD 0.95824f
C6 XM14.G VDD 0.11763f
C7 GND XM14.D 0
C8 Vref XR3.R1 0.07156f
C9 XM14.G GND 0.35977f
C10 XM5.D VOUT 0
C11 VOUT XM8.S 0.00549f
C12 XM14.G XM14.D 0.94f
C13 XM4.G XM6.G 0.15016f
C14 XM7.D VOUT 27.1064f
C15 VDD VOUT 0.34511p
C16 XR2.R1 XM8.S 0.26987f
C17 GND VOUT 0.00313f
C18 XM12.B XM4.G 1.37815f
C19 XR2.R1 XM7.D 0.00173f
C20 XM5.D XM6.G 0.04832f
C21 XR2.R1 GND 0.27124f
C22 XM5.D XM12.B 0
C23 XR3.R1 XM4.G 0.15304f
C24 Vref XM4.G 0.43589f
C25 XM8.S XM6.G 0.17083f
C26 XM5.D XR3.R1 0.08613f
C27 XM7.D XM6.G 79.5969f
C28 VDD XM6.G 1.41824f
C29 Vref XM5.D 0.05669f
C30 XM12.B XM8.S 0.32412f
C31 GND XM6.G 0.0084f
C32 XM12.B XM7.D 16.5574f
C33 XR2.R1 XM14.D 0.1296f
C34 XM14.G XR2.R1 0.17334f
C35 VDD XM12.B 15.5236f
C36 GND XM12.B 0
C37 XM8.S XR3.R1 0.09745f
C38 XM7.D XR3.R1 3.12058f
C39 Vref XM8.S 0.26296f
C40 VDD XR3.R1 0.04155f
C41 GND XR3.R1 0.01129f
C42 Vref XM7.D 0.04804f
C43 Vref VDD 0.06438f
C44 XM14.D XM6.G 0.05887f
C45 Vref GND 0.03791f
C46 XM14.G XM6.G 0.02293f
C47 XM14.D XM12.B 2.09181f
C48 XM14.G XM12.B 0.24607f
C49 XM5.D XM4.G 0.07055f
C50 XM14.D XR3.R1 0
C51 Vref XM14.D 0.47987f
C52 Vref XM14.G 0.82049f
C53 VOUT XM6.G 0.01331f
C54 XM8.S XM4.G 0.51556f
C55 XR2.R1 XM6.G 0.00199f
C56 XM12.B VOUT 1.12562f
C57 XM7.D XM4.G 0.05246f
C58 VDD XM4.G 0.50962f
C59 XM5.D XM8.S 0.40553f
C60 XR2.R1 XM12.B 0.00134f
C61 XM5.D XM7.D 0.00288f
C62 VOUT XR3.R1 7.98875f
C63 GND XM5.D 0.0711f
C64 Vref XR2.R1 0.01325f
C65 XM7.D XM8.S 0.16045f
C66 XM12.B XM6.G 1.42577f
C67 VDD XM8.S 0.12027f
C68 XM14.D XM4.G 0.00526f
C69 XM14.G XM4.G 0
C70 GND XM8.S 1.32635f
C71 VDD XM7.D 35.5f
C72 GND XM7.D 0.68669f
C73 XM14.G XM5.D 0
C74 XR3.R1 XM6.G 0.56712f
C75 Vref XM6.G 0.03249f
C76 XM12.B XR3.R1 0.57716f
C77 VOUT XR3.B 0.19125p
C78 Vref XR3.B 1.64363f
C79 GND XR3.B 9.76313f
C80 VDD XR3.B 0.1862p
C81 XR3.R1 XR3.B 8.90774f
C82 XM5.D XR3.B 0.76441f
C83 XR2.R1 XR3.B 1.07739f
C84 XM7.D XR3.B 19.9529f
C85 XM6.G XR3.B 42.28535f
C86 XM4.G XR3.B 0.60156f
C87 XM8.S XR3.B 3.4922f
C88 XM14.G XR3.B 2.66865f
C89 XM14.D XR3.B 1.47732f
C90 XM12.B XR3.B 0.17397p
C91 XM6.G.t1 XR3.B 0.00882f
C92 XM6.G.t3 XR3.B 39.9368f
C93 XM6.G.t2 XR3.B 0.05131f
C94 XM6.G.n0 XR3.B 0.18073f
C95 XM6.G.t0 XR3.B 0.006f
C96 XR3.R1.t2 XR3.B 0.22493f
C97 XR3.R1.t1 XR3.B 0.03179f
C98 XR3.R1.n0 XR3.B 0.21133f
C99 XR3.R1.t0 XR3.B 0.03179f
C100 XR3.R1.n1 XR3.B 0.16448f
C101 XR3.R1.n2 XR3.B 8.051f
C102 XM14.D.t4 XR3.B 0.1723f
C103 XM14.D.t2 XR3.B 0.02836f
C104 XM14.D.t3 XR3.B 0.17243f
C105 XM14.D.n0 XR3.B 0.37624f
C106 XM14.D.t1 XR3.B 0.17205f
C107 XM14.D.n1 XR3.B 0.18259f
C108 XM14.D.n2 XR3.B 0.67452f
C109 XM14.D.t0 XR3.B 0.05844f
C110 VDD.t0 XR3.B 0.06112f
C111 VDD.t2 XR3.B 0.03155f
C112 VDD.t3 XR3.B 0.03155f
C113 VDD.n0 XR3.B 0.28607f
C114 VDD.t55 XR3.B 0.25786f
C115 VDD.n1 XR3.B 2.85104f
C116 VDD.n2 XR3.B 0.94649f
C117 VDD.t4 XR3.B 0.06112f
C118 VDD.t1 XR3.B 0.06112f
C119 VDD.n3 XR3.B 0.45445f
C120 VDD.n4 XR3.B 0.88396f
C121 VDD.n5 XR3.B 5.59461f
C122 VDD.t37 XR3.B 0.59151f
C123 VDD.t39 XR3.B 0.59151f
C124 VDD.n6 XR3.B 1.18303f
C125 VDD.t45 XR3.B 0.59151f
C126 VDD.t32 XR3.B 0.59151f
C127 VDD.n7 XR3.B 1.18303f
C128 VDD.t47 XR3.B 0.59151f
C129 VDD.t54 XR3.B 0.59151f
C130 VDD.n8 XR3.B 1.18303f
C131 VDD.t10 XR3.B 0.59151f
C132 VDD.t52 XR3.B 0.59151f
C133 VDD.n9 XR3.B 1.18303f
C134 VDD.t19 XR3.B 0.59151f
C135 VDD.t24 XR3.B 0.59151f
C136 VDD.n10 XR3.B 1.18303f
C137 VDD.t27 XR3.B 0.59151f
C138 VDD.t30 XR3.B 0.59151f
C139 VDD.n11 XR3.B 1.18303f
C140 VDD.t33 XR3.B 0.59151f
C141 VDD.t23 XR3.B 0.59151f
C142 VDD.n12 XR3.B 1.18303f
C143 VDD.t9 XR3.B 0.59151f
C144 VDD.t49 XR3.B 0.59151f
C145 VDD.n13 XR3.B 1.18303f
C146 VDD.t53 XR3.B 0.59151f
C147 VDD.t44 XR3.B 0.59151f
C148 VDD.n14 XR3.B 1.18303f
C149 VDD.n15 XR3.B 1.98733f
C150 VDD.n16 XR3.B 9.36682f
C151 VDD.t51 XR3.B 0.59151f
C152 VDD.t42 XR3.B 0.59151f
C153 VDD.n17 XR3.B 1.18303f
C154 VDD.t46 XR3.B 0.59151f
C155 VDD.t48 XR3.B 0.59151f
C156 VDD.n18 XR3.B 1.18303f
C157 VDD.t15 XR3.B 0.59151f
C158 VDD.t6 XR3.B 0.59151f
C159 VDD.n19 XR3.B 1.18303f
C160 VDD.t11 XR3.B 0.59151f
C161 VDD.t14 XR3.B 0.59151f
C162 VDD.n20 XR3.B 1.18303f
C163 VDD.t36 XR3.B 0.59151f
C164 VDD.t25 XR3.B 0.59151f
C165 VDD.n21 XR3.B 1.18303f
C166 VDD.t43 XR3.B 0.59151f
C167 VDD.t31 XR3.B 0.59151f
C168 VDD.n22 XR3.B 1.18303f
C169 VDD.t40 XR3.B 0.59151f
C170 VDD.t41 XR3.B 0.59151f
C171 VDD.n23 XR3.B 1.18303f
C172 VDD.t8 XR3.B 0.59151f
C173 VDD.t50 XR3.B 0.59151f
C174 VDD.n24 XR3.B 1.18303f
C175 VDD.t5 XR3.B 0.59151f
C176 VDD.t22 XR3.B 0.59151f
C177 VDD.n25 XR3.B 1.18303f
C178 VDD.t26 XR3.B 0.59151f
C179 VDD.t13 XR3.B 0.59151f
C180 VDD.n26 XR3.B 1.18303f
C181 VDD.t38 XR3.B 0.59151f
C182 VDD.t21 XR3.B 0.59151f
C183 VDD.n27 XR3.B 1.18303f
C184 VDD.t35 XR3.B 5.58153f
C185 VDD.n28 XR3.B 6.46627f
C186 VDD.n29 XR3.B 2.19713f
C187 VDD.n30 XR3.B 2.19713f
C188 VDD.n31 XR3.B 4.92587f
C189 VDD.n32 XR3.B 2.19713f
C190 VDD.n33 XR3.B 2.19713f
C191 VDD.n34 XR3.B 2.1272f
C192 VDD.n35 XR3.B 0.74595f
C193 VDD.n36 XR3.B 1.52111f
C194 VDD.n37 XR3.B 2.19713f
C195 VDD.n38 XR3.B 2.19713f
C196 VDD.n39 XR3.B 2.05727f
C197 VDD.t29 XR3.B 0.59151f
C198 VDD.t34 XR3.B 0.59151f
C199 VDD.n40 XR3.B 1.18303f
C200 VDD.t18 XR3.B 0.59151f
C201 VDD.t20 XR3.B 0.59151f
C202 VDD.n41 XR3.B 1.18303f
C203 VDD.t7 XR3.B 0.59151f
C204 VDD.t12 XR3.B 0.59151f
C205 VDD.n42 XR3.B 1.18303f
C206 VDD.n43 XR3.B 2.19713f
C207 VDD.n44 XR3.B 2.19713f
C208 VDD.n45 XR3.B 1.59105f
C209 VDD.n46 XR3.B 0.74595f
C210 VDD.n47 XR3.B 5.59461f
C211 VDD.n48 XR3.B 5.59461f
C212 VDD.n49 XR3.B 0.74595f
C213 VDD.n50 XR3.B 1.66098f
C214 VDD.n51 XR3.B 2.19713f
C215 VDD.n52 XR3.B 2.19713f
C216 VDD.n53 XR3.B 1.9174f
C217 VDD.n54 XR3.B 0.74595f
C218 VDD.n55 XR3.B 1.73091f
C219 VDD.n56 XR3.B 2.19713f
C220 VDD.n57 XR3.B 2.19713f
C221 VDD.n58 XR3.B 1.84747f
C222 VDD.t28 XR3.B 0.59151f
C223 VDD.t16 XR3.B 0.59151f
C224 VDD.n59 XR3.B 1.18303f
C225 VDD.t17 XR3.B 2.1431f
C226 VDD.n60 XR3.B 3.58372f
C227 VDD.n61 XR3.B 0.74595f
C228 VDD.n62 XR3.B 40.0986f
C229 VDD.n63 XR3.B 54.0263f
C230 VDD.n64 XR3.B 0.51366f
C231 VDD.n65 XR3.B 0.01948f
C232 VOUT.t1 XR3.B 0.66455f
C233 VOUT.t34 XR3.B 0.66455f
C234 VOUT.n0 XR3.B 1.3291f
C235 VOUT.t23 XR3.B 0.66455f
C236 VOUT.t43 XR3.B 0.66455f
C237 VOUT.n1 XR3.B 1.3291f
C238 VOUT.t18 XR3.B 0.66455f
C239 VOUT.t47 XR3.B 0.66455f
C240 VOUT.n2 XR3.B 1.3291f
C241 VOUT.n3 XR3.B 4.50617f
C242 VOUT.n4 XR3.B 4.62239f
C243 VOUT.t15 XR3.B 0.66455f
C244 VOUT.t33 XR3.B 0.66455f
C245 VOUT.n5 XR3.B 1.3291f
C246 VOUT.t20 XR3.B 0.66455f
C247 VOUT.t22 XR3.B 0.66455f
C248 VOUT.n6 XR3.B 1.3291f
C249 VOUT.t40 XR3.B 0.66455f
C250 VOUT.t17 XR3.B 0.66455f
C251 VOUT.n7 XR3.B 1.3291f
C252 VOUT.t6 XR3.B 0.66455f
C253 VOUT.t9 XR3.B 0.66455f
C254 VOUT.n8 XR3.B 1.3291f
C255 VOUT.t8 XR3.B 0.66455f
C256 VOUT.t5 XR3.B 0.66455f
C257 VOUT.n9 XR3.B 1.3291f
C258 VOUT.t36 XR3.B 0.66455f
C259 VOUT.t44 XR3.B 0.66455f
C260 VOUT.n10 XR3.B 1.3291f
C261 VOUT.t49 XR3.B 0.66455f
C262 VOUT.t16 XR3.B 0.66455f
C263 VOUT.n11 XR3.B 1.3291f
C264 VOUT.t10 XR3.B 0.66455f
C265 VOUT.t26 XR3.B 0.66455f
C266 VOUT.n12 XR3.B 1.3291f
C267 VOUT.t39 XR3.B 0.66455f
C268 VOUT.t38 XR3.B 0.66455f
C269 VOUT.n13 XR3.B 1.3291f
C270 VOUT.n14 XR3.B 5.1223f
C271 VOUT.t42 XR3.B 0.66455f
C272 VOUT.t4 XR3.B 0.66455f
C273 VOUT.n15 XR3.B 1.3291f
C274 VOUT.t2 XR3.B 0.66455f
C275 VOUT.t24 XR3.B 0.66455f
C276 VOUT.n16 XR3.B 1.3291f
C277 VOUT.t35 XR3.B 0.66455f
C278 VOUT.t31 XR3.B 0.66455f
C279 VOUT.n17 XR3.B 1.3291f
C280 VOUT.t12 XR3.B 0.66455f
C281 VOUT.t48 XR3.B 0.66455f
C282 VOUT.n18 XR3.B 1.3291f
C283 VOUT.n19 XR3.B 3.16933f
C284 VOUT.n20 XR3.B 4.74318f
C285 VOUT.n21 XR3.B 3.34238f
C286 VOUT.n22 XR3.B 5.51884f
C287 VOUT.t41 XR3.B 0.66455f
C288 VOUT.t50 XR3.B 0.66455f
C289 VOUT.n23 XR3.B 1.3291f
C290 VOUT.t21 XR3.B 0.66455f
C291 VOUT.t46 XR3.B 0.66455f
C292 VOUT.n24 XR3.B 1.3291f
C293 VOUT.t45 XR3.B 0.66455f
C294 VOUT.t3 XR3.B 0.66455f
C295 VOUT.n25 XR3.B 1.3291f
C296 VOUT.t30 XR3.B 0.66455f
C297 VOUT.t25 XR3.B 0.66455f
C298 VOUT.n26 XR3.B 1.3291f
C299 VOUT.n27 XR3.B 4.74578f
C300 VOUT.n28 XR3.B 5.13941f
C301 VOUT.n29 XR3.B 5.13941f
C302 VOUT.n30 XR3.B 3.137f
C303 VOUT.t7 XR3.B 0.66455f
C304 VOUT.t37 XR3.B 0.66455f
C305 VOUT.n31 XR3.B 1.3291f
C306 VOUT.t27 XR3.B 0.66455f
C307 VOUT.t29 XR3.B 0.66455f
C308 VOUT.n32 XR3.B 1.3291f
C309 VOUT.n33 XR3.B 5.13941f
C310 VOUT.n34 XR3.B 4.95115f
C311 VOUT.n35 XR3.B 2.19067f
C312 VOUT.n36 XR3.B 8.00594f
C313 VOUT.n37 XR3.B 4.62239f
C314 VOUT.n38 XR3.B 2.19067f
C315 VOUT.n39 XR3.B 2.96585f
C316 VOUT.n40 XR3.B 5.13941f
C317 VOUT.n41 XR3.B 5.13941f
C318 VOUT.n42 XR3.B 4.91692f
C319 VOUT.n43 XR3.B 2.19067f
C320 VOUT.n44 XR3.B 3.17123f
C321 VOUT.n45 XR3.B 5.13941f
C322 VOUT.n46 XR3.B 5.13941f
C323 VOUT.n47 XR3.B 4.71155f
C324 VOUT.t11 XR3.B 0.66455f
C325 VOUT.t32 XR3.B 0.66455f
C326 VOUT.n48 XR3.B 1.3291f
C327 VOUT.t19 XR3.B 0.66455f
C328 VOUT.t28 XR3.B 0.66455f
C329 VOUT.n49 XR3.B 1.3291f
C330 VOUT.t13 XR3.B 0.66455f
C331 VOUT.t14 XR3.B 0.66455f
C332 VOUT.n50 XR3.B 1.3291f
C333 VOUT.n51 XR3.B 5.13941f
C334 VOUT.n52 XR3.B 5.13941f
C335 VOUT.n53 XR3.B 3.37661f
C336 VOUT.n54 XR3.B 2.19067f
C337 VOUT.n55 XR3.B 4.62078f
C338 VOUT.n56 XR3.B 4.35591f
C339 VOUT.n57 XR3.B 2.19067f
C340 VOUT.n58 XR3.B 3.58198f
C341 VOUT.t0 XR3.B 0.05494f
C342 VOUT.n59 XR3.B 2.89149f
C343 VOUT.n60 XR3.B 4.7114f
.ends
