** sch_path: /home/weiteck/Desktop/projects/UREx-LDO(skywater)/xschem/UREx-LDO-v4.sch
.subckt UREx-LDO-v4 VDD VOUT GND Vref
*.PININFO VDD:I VOUT:O GND:I Vref:I
XM1 net3 Vref net1 GND sky130_fd_pr__nfet_01v8_lvt L=1 W=0.8 nf=1 m=1
XM2 net2 v+ net1 GND sky130_fd_pr__nfet_01v8_lvt L=1 W=0.8 nf=1 m=1
XM4 net2 net3 VDD VDD sky130_fd_pr__pfet_01v8_lvt L=1 W=0.5 nf=1 m=1
XM3 net3 net3 VDD VDD sky130_fd_pr__pfet_01v8_lvt L=1 W=0.5 nf=1 m=1
XM6 gate net2 VDD VDD sky130_fd_pr__pfet_01v8_lvt L=0.35 W=4.2 nf=1 m=1
XM7 gate net4 GND GND sky130_fd_pr__nfet_01v8_lvt L=0.25 W=5.2 nf=1 m=1
XM9 VOUT gate VDD VDD sky130_fd_pr__pfet_01v8_lvt L=0.35 W=350 nf=14 m=1
XM10 net4 net5 VDD VDD sky130_fd_pr__pfet_01v8_lvt L=1 W=1 nf=1 m=1
XM11 net5 net5 VDD VDD sky130_fd_pr__pfet_01v8_lvt L=1 W=1 nf=1 m=1
XM12 net7 net5 VDD VDD sky130_fd_pr__pfet_01v8_lvt L=1 W=1 nf=1 m=1
XM13 net7 net7 GND GND sky130_fd_pr__nfet_01v8_lvt L=1 W=2 nf=1 m=1
XM14 net5 net7 net6 net6 sky130_fd_pr__nfet_01v8_lvt L=1 W=2.2 nf=1 m=1
XR1 v+ VOUT GND sky130_fd_pr__res_high_po_0p35 L=35.7 mult=1 m=1
XR3 GND v+ GND sky130_fd_pr__res_high_po_0p35 L=53.9 mult=1 m=1
XR2 GND net6 GND sky130_fd_pr__res_high_po_0p35 L=3.1 mult=1 m=1
XC1 gate net2 sky130_fd_pr__cap_mim_m3_1 W=50 L=50 m=1
XM5 net1 net4 GND GND sky130_fd_pr__nfet_01v8_lvt L=1 W=1.2 nf=1 m=1
XM8 net4 net4 GND GND sky130_fd_pr__nfet_01v8_lvt L=1 W=1.2 nf=1 m=1
XM15 VOUT gate VDD VDD sky130_fd_pr__pfet_01v8_lvt L=0.35 W=350 nf=14 m=1
XM16 VOUT gate VDD VDD sky130_fd_pr__pfet_01v8_lvt L=0.35 W=350 nf=14 m=1
XM17 VOUT gate VDD VDD sky130_fd_pr__pfet_01v8_lvt L=0.35 W=350 nf=14 m=1
XM18 VOUT gate VDD VDD sky130_fd_pr__pfet_01v8_lvt L=0.35 W=350 nf=14 m=1
.ends
